* NGSPICE file created from layer_output.ext - technology: sky130A

* Black-box entry subcircuit for neurona abstract view
.subckt neurona vdd vss Iin spike_neg spike
.ends

.subckt layer_output Iext1 Iext2 nvout_1 nvout_2 vdd vout_1 vout_2 vss
Xx1 vdd vss Iext1 nvout_1 vout_1 neurona
Xx2 vdd vss Iext2 nvout_2 vout_2 neurona
.ends
