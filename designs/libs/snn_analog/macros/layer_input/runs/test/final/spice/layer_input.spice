* NGSPICE file created from layer_input.ext - technology: sky130A

* Black-box entry subcircuit for neurona abstract view
.subckt neurona vdd vss Iin spike_neg spike
.ends

.subckt layer_input Iext1 Iext2 Iext3 Iext4 nvout_1 nvout_2 nvout_3 nvout_4 vdd vout_1
+ vout_2 vout_3 vout_4 vss
Xx1 vdd vss Iext1 nvout_1 vout_1 neurona
Xx2 vdd vss Iext2 nvout_2 vout_2 neurona
Xx3 vdd vss Iext3 nvout_3 vout_3 neurona
Xx4 vdd vss Iext4 nvout_4 vout_4 neurona
.ends
