* NGSPICE file created from Current_limit.ext - technology: gf180mcuD

.subckt M1 a_500_n131# a_n500_n339# w_n886_n560# a_n620_n131# VSUBS
X0 a_500_n131# a_n500_n339# a_n620_n131# w_n886_n560# pfet_03v3 ad=0.3p pd=2.2u as=0.3p ps=2.2u w=0.5u l=5u
C0 w_n886_n560# a_n500_n339# 2.19386f
C1 a_n620_n131# a_500_n131# 0.60702f
C2 a_n620_n131# w_n886_n560# 0.31737f
C3 w_n886_n560# a_500_n131# 0.93149f
C4 a_n620_n131# a_n500_n339# 0.23019f
C5 a_500_n131# a_n500_n339# 0.0502f
C6 a_500_n131# VSUBS 0.03729f
C7 a_n620_n131# VSUBS 0.03729f
C8 a_n500_n339# VSUBS 0.13047f
C9 w_n886_n560# VSUBS 7.25551f
.ends

.subckt M1$1 a_500_n131# a_n830_n504# a_n500_n339# a_n620_n131#
X0 a_500_n131# a_n500_n339# a_n620_n131# a_n830_n504# nfet_03v3 ad=0.3p pd=2.2u as=0.3p ps=2.2u w=0.5u l=5u
C0 a_n500_n339# a_n620_n131# 0.23019f
C1 a_500_n131# a_n500_n339# 0.0502f
C2 a_500_n131# a_n620_n131# 0.60702f
C3 a_500_n131# a_n830_n504# 0.96878f
C4 a_n620_n131# a_n830_n504# 0.35466f
C5 a_n500_n339# a_n830_n504# 2.32433f
.ends

.subckt M0 a_500_n131# a_n500_n339# w_n886_n560# a_n620_n131# VSUBS
X0 a_500_n131# a_n500_n339# a_n620_n131# w_n886_n560# pfet_03v3 ad=0.3p pd=2.2u as=0.3p ps=2.2u w=0.5u l=5u
C0 w_n886_n560# a_n500_n339# 2.19386f
C1 a_n620_n131# a_500_n131# 0.60702f
C2 a_n620_n131# w_n886_n560# 0.31737f
C3 w_n886_n560# a_500_n131# 0.93149f
C4 a_n620_n131# a_n500_n339# 0.23019f
C5 a_500_n131# a_n500_n339# 0.0502f
C6 a_500_n131# VSUBS 0.03729f
C7 a_n620_n131# VSUBS 0.03729f
C8 a_n500_n339# VSUBS 0.13047f
C9 w_n886_n560# VSUBS 7.25551f
.ends

.subckt Current_limit i_SUM ifwd avdd avss
XM1_0 ifwd ifwd avdd M0_0/a_500_n131# avss M1
XM1$1_0 avss avss avss avss M1$1
XM0_0 M0_0/a_500_n131# M0_0/a_500_n131# avdd i_SUM avss M0
R0 avss.n48 avss.n47 20558.4
R1 avss.n49 avss.n48 20328.1
R2 avss.n48 avss.n15 12181.2
R3 avss.n47 avss.n16 408.433
R4 avss.n49 avss.n14 408.433
R5 avss.n17 avss.n16 279.271
R6 avss.n28 avss.n26 279.271
R7 avss.n29 avss.n28 279.271
R8 avss.n30 avss.n29 279.271
R9 avss.n31 avss.n30 279.271
R10 avss.n31 avss.n14 279.271
R11 avss.n26 avss.n15 218.179
R12 avss.n46 avss.n45 64.7505
R13 avss.n46 avss.n2 64.7505
R14 avss.n50 avss.n12 64.7505
R15 avss.n50 avss.n13 64.7505
R16 avss.n17 avss.n15 61.0907
R17 avss.n45 avss.n18 15.5561
R18 avss.n25 avss.n18 15.5561
R19 avss.n25 avss.n22 15.5561
R20 avss.n23 avss.n22 15.5561
R21 avss.n24 avss.n23 15.5561
R22 avss.n32 avss.n24 15.5561
R23 avss.n32 avss.n12 15.5561
R24 avss.n3 avss.n2 15.5561
R25 avss.n4 avss.n3 15.5561
R26 avss.n27 avss.n4 15.5561
R27 avss.n27 avss.n7 15.5561
R28 avss.n8 avss.n7 15.5561
R29 avss.n9 avss.n8 15.5561
R30 avss.n13 avss.n9 15.5561
R31 avss avss.n71 15.3676
R32 avss.n70 avss.n69 12.2015
R33 avss.n69 avss.n68 9.8285
R34 avss.n45 avss.n44 5.2005
R35 avss.n45 avss.n16 5.2005
R36 avss.n43 avss.n18 5.2005
R37 avss.n18 avss.n17 5.2005
R38 avss.n25 avss.n20 5.2005
R39 avss.n26 avss.n25 5.2005
R40 avss.n39 avss.n22 5.2005
R41 avss.n28 avss.n22 5.2005
R42 avss.n38 avss.n23 5.2005
R43 avss.n29 avss.n23 5.2005
R44 avss.n37 avss.n24 5.2005
R45 avss.n30 avss.n24 5.2005
R46 avss.n34 avss.n32 5.2005
R47 avss.n32 avss.n31 5.2005
R48 avss.n33 avss.n12 5.2005
R49 avss.n14 avss.n12 5.2005
R50 avss.n13 avss.n10 5.2005
R51 avss.n14 avss.n13 5.2005
R52 avss.n54 avss.n9 5.2005
R53 avss.n31 avss.n9 5.2005
R54 avss.n55 avss.n8 5.2005
R55 avss.n30 avss.n8 5.2005
R56 avss.n56 avss.n7 5.2005
R57 avss.n29 avss.n7 5.2005
R58 avss.n27 avss.n5 5.2005
R59 avss.n28 avss.n27 5.2005
R60 avss.n60 avss.n4 5.2005
R61 avss.n26 avss.n4 5.2005
R62 avss.n61 avss.n3 5.2005
R63 avss.n17 avss.n3 5.2005
R64 avss.n62 avss.n2 5.2005
R65 avss.n16 avss.n2 5.2005
R66 avss.n52 avss.n51 5.16141
R67 avss.n51 avss.n11 5.16141
R68 avss.n19 avss.n0 5.16141
R69 avss.n64 avss.n63 4.87478
R70 avss.n68 avss.n65 4.85463
R71 avss.n65 avss.n64 4.7147
R72 avss.n67 avss.n66 4.62619
R73 avss.n68 avss.n67 4.60145
R74 avss.n61 avss.n1 4.5005
R75 avss.n60 avss.n59 4.5005
R76 avss.n58 avss.n5 4.5005
R77 avss.n57 avss.n56 4.5005
R78 avss.n55 avss.n6 4.5005
R79 avss.n54 avss.n53 4.5005
R80 avss.n52 avss.n10 4.5005
R81 avss.n63 avss.n62 4.5005
R82 avss.n35 avss.n34 4.5005
R83 avss.n37 avss.n36 4.5005
R84 avss.n38 avss.n21 4.5005
R85 avss.n40 avss.n39 4.5005
R86 avss.n41 avss.n20 4.5005
R87 avss.n43 avss.n42 4.5005
R88 avss.n44 avss.n19 4.5005
R89 avss.n33 avss.n11 4.5005
R90 avss.n71 avss.n65 0.7439
R91 avss.n51 avss.n50 0.743357
R92 avss.n50 avss.n49 0.743357
R93 avss.n46 avss.n0 0.743357
R94 avss.n47 avss.n46 0.743357
R95 avss.n64 avss.n0 0.279304
R96 avss.n44 avss.n43 0.1445
R97 avss.n43 avss.n20 0.1445
R98 avss.n39 avss.n20 0.1445
R99 avss.n39 avss.n38 0.1445
R100 avss.n38 avss.n37 0.1445
R101 avss.n37 avss.n34 0.1445
R102 avss.n34 avss.n33 0.1445
R103 avss.n62 avss.n61 0.1445
R104 avss.n61 avss.n60 0.1445
R105 avss.n60 avss.n5 0.1445
R106 avss.n56 avss.n5 0.1445
R107 avss.n56 avss.n55 0.1445
R108 avss.n55 avss.n54 0.1445
R109 avss.n54 avss.n10 0.1445
R110 avss.n63 avss.n1 0.1445
R111 avss.n59 avss.n1 0.1445
R112 avss.n59 avss.n58 0.1445
R113 avss.n58 avss.n57 0.1445
R114 avss.n57 avss.n6 0.1445
R115 avss.n53 avss.n6 0.1445
R116 avss.n53 avss.n52 0.1445
R117 avss.n42 avss.n19 0.1445
R118 avss.n42 avss.n41 0.1445
R119 avss.n41 avss.n40 0.1445
R120 avss.n40 avss.n21 0.1445
R121 avss.n36 avss.n21 0.1445
R122 avss.n36 avss.n35 0.1445
R123 avss.n35 avss.n11 0.1445
R124 avss.n71 avss.n70 0.0995
R125 avss.n70 avss.n67 0.0577854
R126 avdd.n33 avdd.n23 142.857
R127 avdd.n33 avdd.n17 142.857
R128 avdd.n41 avdd.n17 142.857
R129 avdd.n41 avdd.n11 142.857
R130 avdd.n49 avdd.n11 142.857
R131 avdd.n49 avdd.n5 142.857
R132 avdd.n121 avdd.n5 142.857
R133 avdd.n87 avdd.n77 142.857
R134 avdd.n87 avdd.n71 142.857
R135 avdd.n95 avdd.n71 142.857
R136 avdd.n95 avdd.n65 142.857
R137 avdd.n103 avdd.n65 142.857
R138 avdd.n103 avdd.n59 142.857
R139 avdd.n111 avdd.n59 142.857
R140 avdd.n120 avdd.n4 58.2755
R141 avdd.n27 avdd.n24 58.2755
R142 avdd.n110 avdd.n58 58.2755
R143 avdd.n81 avdd.n78 58.2755
R144 avdd.n122 avdd.n4 44.5622
R145 avdd.n27 avdd.n26 44.5622
R146 avdd.n112 avdd.n58 44.5622
R147 avdd.n81 avdd.n80 44.5622
R148 avdd.n34 avdd.n22 14.0005
R149 avdd.n34 avdd.n18 14.0005
R150 avdd.n40 avdd.n18 14.0005
R151 avdd.n40 avdd.n10 14.0005
R152 avdd.n50 avdd.n10 14.0005
R153 avdd.n50 avdd.n6 14.0005
R154 avdd.n120 avdd.n6 14.0005
R155 avdd.n32 avdd.n24 14.0005
R156 avdd.n32 avdd.n16 14.0005
R157 avdd.n42 avdd.n16 14.0005
R158 avdd.n42 avdd.n12 14.0005
R159 avdd.n48 avdd.n12 14.0005
R160 avdd.n48 avdd.n3 14.0005
R161 avdd.n123 avdd.n3 14.0005
R162 avdd.n88 avdd.n76 14.0005
R163 avdd.n88 avdd.n72 14.0005
R164 avdd.n94 avdd.n72 14.0005
R165 avdd.n94 avdd.n64 14.0005
R166 avdd.n104 avdd.n64 14.0005
R167 avdd.n104 avdd.n60 14.0005
R168 avdd.n110 avdd.n60 14.0005
R169 avdd.n86 avdd.n78 14.0005
R170 avdd.n86 avdd.n70 14.0005
R171 avdd.n96 avdd.n70 14.0005
R172 avdd.n96 avdd.n66 14.0005
R173 avdd.n102 avdd.n66 14.0005
R174 avdd.n102 avdd.n57 14.0005
R175 avdd.n113 avdd.n57 14.0005
R176 avdd avdd.n126 13.3723
R177 avdd.n120 avdd.n119 6.3005
R178 avdd.n121 avdd.n120 6.3005
R179 avdd.n7 avdd.n6 6.3005
R180 avdd.n6 avdd.n5 6.3005
R181 avdd.n51 avdd.n50 6.3005
R182 avdd.n50 avdd.n49 6.3005
R183 avdd.n10 avdd.n9 6.3005
R184 avdd.n11 avdd.n10 6.3005
R185 avdd.n40 avdd.n39 6.3005
R186 avdd.n41 avdd.n40 6.3005
R187 avdd.n19 avdd.n18 6.3005
R188 avdd.n18 avdd.n17 6.3005
R189 avdd.n35 avdd.n34 6.3005
R190 avdd.n34 avdd.n33 6.3005
R191 avdd.n22 avdd.n21 6.3005
R192 avdd.n25 avdd.n24 6.3005
R193 avdd.n24 avdd.n23 6.3005
R194 avdd.n32 avdd.n31 6.3005
R195 avdd.n33 avdd.n32 6.3005
R196 avdd.n16 avdd.n15 6.3005
R197 avdd.n17 avdd.n16 6.3005
R198 avdd.n43 avdd.n42 6.3005
R199 avdd.n42 avdd.n41 6.3005
R200 avdd.n13 avdd.n12 6.3005
R201 avdd.n12 avdd.n11 6.3005
R202 avdd.n48 avdd.n47 6.3005
R203 avdd.n49 avdd.n48 6.3005
R204 avdd.n3 avdd.n2 6.3005
R205 avdd.n5 avdd.n3 6.3005
R206 avdd.n124 avdd.n123 6.3005
R207 avdd.n110 avdd.n109 6.3005
R208 avdd.n111 avdd.n110 6.3005
R209 avdd.n61 avdd.n60 6.3005
R210 avdd.n60 avdd.n59 6.3005
R211 avdd.n105 avdd.n104 6.3005
R212 avdd.n104 avdd.n103 6.3005
R213 avdd.n64 avdd.n63 6.3005
R214 avdd.n65 avdd.n64 6.3005
R215 avdd.n94 avdd.n93 6.3005
R216 avdd.n95 avdd.n94 6.3005
R217 avdd.n73 avdd.n72 6.3005
R218 avdd.n72 avdd.n71 6.3005
R219 avdd.n89 avdd.n88 6.3005
R220 avdd.n88 avdd.n87 6.3005
R221 avdd.n76 avdd.n75 6.3005
R222 avdd.n114 avdd.n113 6.3005
R223 avdd.n57 avdd.n56 6.3005
R224 avdd.n59 avdd.n57 6.3005
R225 avdd.n102 avdd.n101 6.3005
R226 avdd.n103 avdd.n102 6.3005
R227 avdd.n67 avdd.n66 6.3005
R228 avdd.n66 avdd.n65 6.3005
R229 avdd.n97 avdd.n96 6.3005
R230 avdd.n96 avdd.n95 6.3005
R231 avdd.n70 avdd.n69 6.3005
R232 avdd.n71 avdd.n70 6.3005
R233 avdd.n86 avdd.n85 6.3005
R234 avdd.n87 avdd.n86 6.3005
R235 avdd.n79 avdd.n78 6.3005
R236 avdd.n78 avdd.n77 6.3005
R237 avdd.n29 avdd.n28 5.16141
R238 avdd.n28 avdd.n20 5.16141
R239 avdd.n83 avdd.n82 5.16141
R240 avdd.n82 avdd.n74 5.16141
R241 avdd.n108 avdd.n54 5.16141
R242 avdd.n26 avdd.n23 4.81843
R243 avdd.n122 avdd.n121 4.81843
R244 avdd.n80 avdd.n77 4.81843
R245 avdd.n112 avdd.n111 4.81843
R246 avdd.n126 avdd.n125 4.7075
R247 avdd.n118 avdd.n117 4.7075
R248 avdd.n116 avdd.n115 4.7075
R249 avdd.n29 avdd.n25 4.5005
R250 avdd.n31 avdd.n30 4.5005
R251 avdd.n15 avdd.n14 4.5005
R252 avdd.n44 avdd.n43 4.5005
R253 avdd.n45 avdd.n13 4.5005
R254 avdd.n47 avdd.n46 4.5005
R255 avdd.n2 avdd.n1 4.5005
R256 avdd.n125 avdd.n124 4.5005
R257 avdd.n36 avdd.n35 4.5005
R258 avdd.n37 avdd.n19 4.5005
R259 avdd.n39 avdd.n38 4.5005
R260 avdd.n9 avdd.n8 4.5005
R261 avdd.n52 avdd.n51 4.5005
R262 avdd.n53 avdd.n7 4.5005
R263 avdd.n119 avdd.n118 4.5005
R264 avdd.n21 avdd.n20 4.5005
R265 avdd.n85 avdd.n84 4.5005
R266 avdd.n69 avdd.n68 4.5005
R267 avdd.n98 avdd.n97 4.5005
R268 avdd.n99 avdd.n67 4.5005
R269 avdd.n101 avdd.n100 4.5005
R270 avdd.n56 avdd.n55 4.5005
R271 avdd.n115 avdd.n114 4.5005
R272 avdd.n83 avdd.n79 4.5005
R273 avdd.n90 avdd.n89 4.5005
R274 avdd.n91 avdd.n73 4.5005
R275 avdd.n93 avdd.n92 4.5005
R276 avdd.n63 avdd.n62 4.5005
R277 avdd.n106 avdd.n105 4.5005
R278 avdd.n107 avdd.n61 4.5005
R279 avdd.n109 avdd.n108 4.5005
R280 avdd.n75 avdd.n74 4.5005
R281 avdd.n123 avdd.n122 1.33893
R282 avdd.n26 avdd.n22 1.33893
R283 avdd.n113 avdd.n112 1.33893
R284 avdd.n80 avdd.n76 1.33893
R285 avdd.n28 avdd.n27 0.9005
R286 avdd.n82 avdd.n81 0.9005
R287 avdd.n58 avdd.n54 0.9005
R288 avdd.n4 avdd.n0 0.9005
R289 avdd.n117 avdd.n116 0.68137
R290 avdd.n116 avdd.n54 0.454413
R291 avdd.n117 avdd.n0 0.454413
R292 avdd.n126 avdd.n0 0.454413
R293 avdd.n35 avdd.n21 0.1445
R294 avdd.n35 avdd.n19 0.1445
R295 avdd.n39 avdd.n19 0.1445
R296 avdd.n39 avdd.n9 0.1445
R297 avdd.n51 avdd.n9 0.1445
R298 avdd.n51 avdd.n7 0.1445
R299 avdd.n119 avdd.n7 0.1445
R300 avdd.n31 avdd.n25 0.1445
R301 avdd.n31 avdd.n15 0.1445
R302 avdd.n43 avdd.n15 0.1445
R303 avdd.n43 avdd.n13 0.1445
R304 avdd.n47 avdd.n13 0.1445
R305 avdd.n47 avdd.n2 0.1445
R306 avdd.n124 avdd.n2 0.1445
R307 avdd.n30 avdd.n29 0.1445
R308 avdd.n30 avdd.n14 0.1445
R309 avdd.n44 avdd.n14 0.1445
R310 avdd.n45 avdd.n44 0.1445
R311 avdd.n46 avdd.n45 0.1445
R312 avdd.n46 avdd.n1 0.1445
R313 avdd.n125 avdd.n1 0.1445
R314 avdd.n36 avdd.n20 0.1445
R315 avdd.n37 avdd.n36 0.1445
R316 avdd.n38 avdd.n37 0.1445
R317 avdd.n38 avdd.n8 0.1445
R318 avdd.n52 avdd.n8 0.1445
R319 avdd.n53 avdd.n52 0.1445
R320 avdd.n118 avdd.n53 0.1445
R321 avdd.n89 avdd.n75 0.1445
R322 avdd.n89 avdd.n73 0.1445
R323 avdd.n93 avdd.n73 0.1445
R324 avdd.n93 avdd.n63 0.1445
R325 avdd.n105 avdd.n63 0.1445
R326 avdd.n105 avdd.n61 0.1445
R327 avdd.n109 avdd.n61 0.1445
R328 avdd.n85 avdd.n79 0.1445
R329 avdd.n85 avdd.n69 0.1445
R330 avdd.n97 avdd.n69 0.1445
R331 avdd.n97 avdd.n67 0.1445
R332 avdd.n101 avdd.n67 0.1445
R333 avdd.n101 avdd.n56 0.1445
R334 avdd.n114 avdd.n56 0.1445
R335 avdd.n84 avdd.n83 0.1445
R336 avdd.n84 avdd.n68 0.1445
R337 avdd.n98 avdd.n68 0.1445
R338 avdd.n99 avdd.n98 0.1445
R339 avdd.n100 avdd.n99 0.1445
R340 avdd.n100 avdd.n55 0.1445
R341 avdd.n115 avdd.n55 0.1445
R342 avdd.n90 avdd.n74 0.1445
R343 avdd.n91 avdd.n90 0.1445
R344 avdd.n92 avdd.n91 0.1445
R345 avdd.n92 avdd.n62 0.1445
R346 avdd.n106 avdd.n62 0.1445
R347 avdd.n107 avdd.n106 0.1445
R348 avdd.n108 avdd.n107 0.1445
R349 ifwd ifwd.n1 14.5893
R350 ifwd ifwd.n0 6.09231
C0 i_SUM avdd 0.06722f
C1 ifwd M0_0/a_500_n131# 0.03231f
C2 i_SUM ifwd 0.01751f
C3 i_SUM M0_0/a_500_n131# 0.35791f
C4 avdd ifwd 0.38549f
C5 avdd M0_0/a_500_n131# 0.86026f
C6 ifwd.n0 avss 0.18412f
C7 ifwd.n1 avss 0.02243f
C8 avdd.n0 avss 0.00608f
C9 avdd.n1 avss 0.00227f
C10 avdd.n2 avss 0.00227f
C11 avdd.n3 avss 0.00164f
C12 avdd.n4 avss 0.04019f
C13 avdd.n5 avss 0.02546f
C14 avdd.n6 avss 0.00164f
C15 avdd.n7 avss 0.00227f
C16 avdd.n8 avss 0.00227f
C17 avdd.n9 avss 0.00227f
C18 avdd.n10 avss 0.00164f
C19 avdd.n11 avss 0.02546f
C20 avdd.n12 avss 0.00164f
C21 avdd.n13 avss 0.00227f
C22 avdd.n14 avss 0.00227f
C23 avdd.n15 avss 0.00227f
C24 avdd.n16 avss 0.00164f
C25 avdd.n17 avss 0.02546f
C26 avdd.n18 avss 0.00164f
C27 avdd.n19 avss 0.00227f
C28 avdd.n20 avss 0.00536f
C29 avdd.n21 avss 0.00185f
C30 avdd.n22 avss 0.00446f
C31 avdd.n23 avss 0.03149f
C32 avdd.n24 avss 0.00446f
C33 avdd.n25 avss 0.00185f
C34 avdd.n27 avss 0.04019f
C35 avdd.n28 avss 0.01328f
C36 avdd.n29 avss 0.00536f
C37 avdd.n30 avss 0.00227f
C38 avdd.n31 avss 0.00227f
C39 avdd.n32 avss 0.00164f
C40 avdd.n33 avss 0.02546f
C41 avdd.n34 avss 0.00164f
C42 avdd.n35 avss 0.00227f
C43 avdd.n36 avss 0.00227f
C44 avdd.n37 avss 0.00227f
C45 avdd.n38 avss 0.00227f
C46 avdd.n39 avss 0.00227f
C47 avdd.n40 avss 0.00164f
C48 avdd.n41 avss 0.02546f
C49 avdd.n42 avss 0.00164f
C50 avdd.n43 avss 0.00227f
C51 avdd.n44 avss 0.00227f
C52 avdd.n45 avss 0.00227f
C53 avdd.n46 avss 0.00227f
C54 avdd.n47 avss 0.00227f
C55 avdd.n48 avss 0.00164f
C56 avdd.n49 avss 0.02546f
C57 avdd.n50 avss 0.00164f
C58 avdd.n51 avss 0.00227f
C59 avdd.n52 avss 0.00227f
C60 avdd.n53 avss 0.00227f
C61 avdd.n54 avss 0.00968f
C62 avdd.n55 avss 0.00227f
C63 avdd.n56 avss 0.00227f
C64 avdd.n57 avss 0.00164f
C65 avdd.n58 avss 0.04019f
C66 avdd.n59 avss 0.02546f
C67 avdd.n60 avss 0.00164f
C68 avdd.n61 avss 0.00227f
C69 avdd.n62 avss 0.00227f
C70 avdd.n63 avss 0.00227f
C71 avdd.n64 avss 0.00164f
C72 avdd.n65 avss 0.02546f
C73 avdd.n66 avss 0.00164f
C74 avdd.n67 avss 0.00227f
C75 avdd.n68 avss 0.00227f
C76 avdd.n69 avss 0.00227f
C77 avdd.n70 avss 0.00164f
C78 avdd.n71 avss 0.02546f
C79 avdd.n72 avss 0.00164f
C80 avdd.n73 avss 0.00227f
C81 avdd.n74 avss 0.00536f
C82 avdd.n75 avss 0.00185f
C83 avdd.n76 avss 0.00446f
C84 avdd.n77 avss 0.03149f
C85 avdd.n78 avss 0.00446f
C86 avdd.n79 avss 0.00185f
C87 avdd.n81 avss 0.04019f
C88 avdd.n82 avss 0.01328f
C89 avdd.n83 avss 0.00536f
C90 avdd.n84 avss 0.00227f
C91 avdd.n85 avss 0.00227f
C92 avdd.n86 avss 0.00164f
C93 avdd.n87 avss 0.02546f
C94 avdd.n88 avss 0.00164f
C95 avdd.n89 avss 0.00227f
C96 avdd.n90 avss 0.00227f
C97 avdd.n91 avss 0.00227f
C98 avdd.n92 avss 0.00227f
C99 avdd.n93 avss 0.00227f
C100 avdd.n94 avss 0.00164f
C101 avdd.n95 avss 0.02546f
C102 avdd.n96 avss 0.00164f
C103 avdd.n97 avss 0.00227f
C104 avdd.n98 avss 0.00227f
C105 avdd.n99 avss 0.00227f
C106 avdd.n100 avss 0.00227f
C107 avdd.n101 avss 0.00227f
C108 avdd.n102 avss 0.00164f
C109 avdd.n103 avss 0.02546f
C110 avdd.n104 avss 0.00164f
C111 avdd.n105 avss 0.00227f
C112 avdd.n106 avss 0.00227f
C113 avdd.n107 avss 0.00227f
C114 avdd.n108 avss 0.00536f
C115 avdd.n109 avss 0.00185f
C116 avdd.n110 avss 0.00446f
C117 avdd.n111 avss 0.03149f
C118 avdd.n113 avss 0.00446f
C119 avdd.n114 avss 0.00185f
C120 avdd.n115 avss 0.00501f
C121 avdd.n116 avss 0.0079f
C122 avdd.n117 avss 0.0079f
C123 avdd.n118 avss 0.00501f
C124 avdd.n119 avss 0.00185f
C125 avdd.n120 avss 0.00446f
C126 avdd.n121 avss 0.03149f
C127 avdd.n123 avss 0.00446f
C128 avdd.n124 avss 0.00185f
C129 avdd.n125 avss 0.00501f
C130 avdd.n126 avss 0.03035f
C131 avss.n0 avss 0.00123f
C132 avss.n1 avss 0
C133 avss.n2 avss 0
C134 avss.n3 avss 0
C135 avss.n4 avss 0
C136 avss.n5 avss 0
C137 avss.n6 avss 0
C138 avss.n7 avss 0
C139 avss.n8 avss 0
C140 avss.n9 avss 0
C141 avss.n10 avss 0
C142 avss.n11 avss 0
C143 avss.n12 avss 0
C144 avss.n13 avss 0
C145 avss.n14 avss 0.00755f
C146 avss.n15 avss 0.01349f
C147 avss.n16 avss 0.00755f
C148 avss.n17 avss 0.00374f
C149 avss.n18 avss 0
C150 avss.n19 avss 0
C151 avss.n20 avss 0
C152 avss.n21 avss 0
C153 avss.n22 avss 0
C154 avss.n23 avss 0
C155 avss.n24 avss 0
C156 avss.n25 avss 0
C157 avss.n26 avss 0.00546f
C158 avss.n27 avss 0
C159 avss.n28 avss 0.00613f
C160 avss.n29 avss 0.00613f
C161 avss.n30 avss 0.00613f
C162 avss.n31 avss 0.00613f
C163 avss.n32 avss 0
C164 avss.n33 avss 0
C165 avss.n34 avss 0
C166 avss.n35 avss 0
C167 avss.n36 avss 0
C168 avss.n37 avss 0
C169 avss.n38 avss 0
C170 avss.n39 avss 0
C171 avss.n40 avss 0
C172 avss.n41 avss 0
C173 avss.n42 avss 0
C174 avss.n43 avss 0
C175 avss.n44 avss 0
C176 avss.n45 avss 0
C177 avss.n46 avss 0.00102f
C178 avss.n47 avss 0.09258f
C179 avss.n48 avss 0.05066f
C180 avss.n49 avss 0.06239f
C181 avss.n50 avss 0.00102f
C182 avss.n51 avss 0.00192f
C183 avss.n52 avss 0
C184 avss.n53 avss 0
C185 avss.n54 avss 0
C186 avss.n55 avss 0
C187 avss.n56 avss 0
C188 avss.n57 avss 0
C189 avss.n58 avss 0
C190 avss.n59 avss 0
C191 avss.n60 avss 0
C192 avss.n61 avss 0
C193 avss.n62 avss 0
C194 avss.n63 avss 0
C195 avss.n64 avss 0
C196 avss.n65 avss 0.00146f
C197 avss.n66 avss 0.00338f
C198 avss.n67 avss 0.00913f
C199 avss.n68 avss 0.00105f
C200 avss.n69 avss 0
C201 avss.n70 avss 0.00692f
C202 avss.n71 avss 0.00544f
C203 ifwd avss -0.1672f
C204 i_SUM avss 0.12632f
C205 avdd avss -1.51961f
C206 M0_0/a_500_n131# avss -0.71669f
.ends
