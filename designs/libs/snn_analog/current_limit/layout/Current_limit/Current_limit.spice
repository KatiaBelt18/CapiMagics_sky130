* NGSPICE file created from Current_limit.ext - technology: gf180mcuD

.subckt M1 a_500_n131# a_n500_n339# w_n886_n560# a_n620_n131# VSUBS
X0 a_500_n131# a_n500_n339# a_n620_n131# w_n886_n560# pfet_03v3 ad=0.3p pd=2.2u as=0.3p ps=2.2u w=0.5u l=5u
C0 a_500_n131# w_n886_n560# 0.93149f
C1 a_500_n131# a_n620_n131# 0.60702f
C2 a_500_n131# a_n500_n339# 0.0502f
C3 a_n620_n131# w_n886_n560# 0.31737f
C4 a_n500_n339# w_n886_n560# 2.19386f
C5 a_n620_n131# a_n500_n339# 0.23019f
C6 a_500_n131# VSUBS 0.03729f
C7 a_n620_n131# VSUBS 0.03729f
C8 a_n500_n339# VSUBS 0.13047f
C9 w_n886_n560# VSUBS 7.25551f
.ends

.subckt M0 a_500_n131# a_n500_n339# w_n886_n560# a_n620_n131# VSUBS
X0 a_500_n131# a_n500_n339# a_n620_n131# w_n886_n560# pfet_03v3 ad=0.3p pd=2.2u as=0.3p ps=2.2u w=0.5u l=5u
C0 a_500_n131# w_n886_n560# 0.93149f
C1 a_500_n131# a_n620_n131# 0.60702f
C2 a_500_n131# a_n500_n339# 0.0502f
C3 a_n620_n131# w_n886_n560# 0.31737f
C4 a_n500_n339# w_n886_n560# 2.19386f
C5 a_n620_n131# a_n500_n339# 0.23019f
C6 a_500_n131# VSUBS 0.03729f
C7 a_n620_n131# VSUBS 0.03729f
C8 a_n500_n339# VSUBS 0.13047f
C9 w_n886_n560# VSUBS 7.25551f
.ends

.subckt Current_limit avdd i_SUM ifwd
XM1_0 ifwd ifwd avdd M0_0/a_500_n131# VSUBS M1
XM0_0 M0_0/a_500_n131# M0_0/a_500_n131# avdd i_SUM VSUBS M0
R0 ifwd ifwd.n1 14.5893
R1 ifwd ifwd.n0 6.09231
R2 avdd.n33 avdd.n23 142.857
R3 avdd.n33 avdd.n17 142.857
R4 avdd.n41 avdd.n17 142.857
R5 avdd.n41 avdd.n11 142.857
R6 avdd.n49 avdd.n11 142.857
R7 avdd.n49 avdd.n5 142.857
R8 avdd.n121 avdd.n5 142.857
R9 avdd.n87 avdd.n77 142.857
R10 avdd.n87 avdd.n71 142.857
R11 avdd.n95 avdd.n71 142.857
R12 avdd.n95 avdd.n65 142.857
R13 avdd.n103 avdd.n65 142.857
R14 avdd.n103 avdd.n59 142.857
R15 avdd.n111 avdd.n59 142.857
R16 avdd.n120 avdd.n4 58.2755
R17 avdd.n27 avdd.n24 58.2755
R18 avdd.n110 avdd.n58 58.2755
R19 avdd.n81 avdd.n78 58.2755
R20 avdd.n122 avdd.n4 44.5622
R21 avdd.n27 avdd.n26 44.5622
R22 avdd.n112 avdd.n58 44.5622
R23 avdd.n81 avdd.n80 44.5622
R24 avdd.n34 avdd.n22 14.0005
R25 avdd.n34 avdd.n18 14.0005
R26 avdd.n40 avdd.n18 14.0005
R27 avdd.n40 avdd.n10 14.0005
R28 avdd.n50 avdd.n10 14.0005
R29 avdd.n50 avdd.n6 14.0005
R30 avdd.n120 avdd.n6 14.0005
R31 avdd.n32 avdd.n24 14.0005
R32 avdd.n32 avdd.n16 14.0005
R33 avdd.n42 avdd.n16 14.0005
R34 avdd.n42 avdd.n12 14.0005
R35 avdd.n48 avdd.n12 14.0005
R36 avdd.n48 avdd.n3 14.0005
R37 avdd.n123 avdd.n3 14.0005
R38 avdd.n88 avdd.n76 14.0005
R39 avdd.n88 avdd.n72 14.0005
R40 avdd.n94 avdd.n72 14.0005
R41 avdd.n94 avdd.n64 14.0005
R42 avdd.n104 avdd.n64 14.0005
R43 avdd.n104 avdd.n60 14.0005
R44 avdd.n110 avdd.n60 14.0005
R45 avdd.n86 avdd.n78 14.0005
R46 avdd.n86 avdd.n70 14.0005
R47 avdd.n96 avdd.n70 14.0005
R48 avdd.n96 avdd.n66 14.0005
R49 avdd.n102 avdd.n66 14.0005
R50 avdd.n102 avdd.n57 14.0005
R51 avdd.n113 avdd.n57 14.0005
R52 avdd.n120 avdd.n119 6.3005
R53 avdd.n121 avdd.n120 6.3005
R54 avdd.n7 avdd.n6 6.3005
R55 avdd.n6 avdd.n5 6.3005
R56 avdd.n51 avdd.n50 6.3005
R57 avdd.n50 avdd.n49 6.3005
R58 avdd.n10 avdd.n9 6.3005
R59 avdd.n11 avdd.n10 6.3005
R60 avdd.n40 avdd.n39 6.3005
R61 avdd.n41 avdd.n40 6.3005
R62 avdd.n19 avdd.n18 6.3005
R63 avdd.n18 avdd.n17 6.3005
R64 avdd.n35 avdd.n34 6.3005
R65 avdd.n34 avdd.n33 6.3005
R66 avdd.n22 avdd.n21 6.3005
R67 avdd.n25 avdd.n24 6.3005
R68 avdd.n24 avdd.n23 6.3005
R69 avdd.n32 avdd.n31 6.3005
R70 avdd.n33 avdd.n32 6.3005
R71 avdd.n16 avdd.n15 6.3005
R72 avdd.n17 avdd.n16 6.3005
R73 avdd.n43 avdd.n42 6.3005
R74 avdd.n42 avdd.n41 6.3005
R75 avdd.n13 avdd.n12 6.3005
R76 avdd.n12 avdd.n11 6.3005
R77 avdd.n48 avdd.n47 6.3005
R78 avdd.n49 avdd.n48 6.3005
R79 avdd.n3 avdd.n2 6.3005
R80 avdd.n5 avdd.n3 6.3005
R81 avdd.n124 avdd.n123 6.3005
R82 avdd.n110 avdd.n109 6.3005
R83 avdd.n111 avdd.n110 6.3005
R84 avdd.n61 avdd.n60 6.3005
R85 avdd.n60 avdd.n59 6.3005
R86 avdd.n105 avdd.n104 6.3005
R87 avdd.n104 avdd.n103 6.3005
R88 avdd.n64 avdd.n63 6.3005
R89 avdd.n65 avdd.n64 6.3005
R90 avdd.n94 avdd.n93 6.3005
R91 avdd.n95 avdd.n94 6.3005
R92 avdd.n73 avdd.n72 6.3005
R93 avdd.n72 avdd.n71 6.3005
R94 avdd.n89 avdd.n88 6.3005
R95 avdd.n88 avdd.n87 6.3005
R96 avdd.n76 avdd.n75 6.3005
R97 avdd.n114 avdd.n113 6.3005
R98 avdd.n57 avdd.n56 6.3005
R99 avdd.n59 avdd.n57 6.3005
R100 avdd.n102 avdd.n101 6.3005
R101 avdd.n103 avdd.n102 6.3005
R102 avdd.n67 avdd.n66 6.3005
R103 avdd.n66 avdd.n65 6.3005
R104 avdd.n97 avdd.n96 6.3005
R105 avdd.n96 avdd.n95 6.3005
R106 avdd.n70 avdd.n69 6.3005
R107 avdd.n71 avdd.n70 6.3005
R108 avdd.n86 avdd.n85 6.3005
R109 avdd.n87 avdd.n86 6.3005
R110 avdd.n79 avdd.n78 6.3005
R111 avdd.n78 avdd.n77 6.3005
R112 avdd.n29 avdd.n28 5.16141
R113 avdd.n28 avdd.n20 5.16141
R114 avdd.n83 avdd.n82 5.16141
R115 avdd.n82 avdd.n74 5.16141
R116 avdd.n108 avdd.n54 5.16141
R117 avdd avdd.n126 5.0767
R118 avdd.n26 avdd.n23 4.81843
R119 avdd.n122 avdd.n121 4.81843
R120 avdd.n80 avdd.n77 4.81843
R121 avdd.n112 avdd.n111 4.81843
R122 avdd.n126 avdd.n125 4.7075
R123 avdd.n118 avdd.n117 4.7075
R124 avdd.n116 avdd.n115 4.7075
R125 avdd.n29 avdd.n25 4.5005
R126 avdd.n31 avdd.n30 4.5005
R127 avdd.n15 avdd.n14 4.5005
R128 avdd.n44 avdd.n43 4.5005
R129 avdd.n45 avdd.n13 4.5005
R130 avdd.n47 avdd.n46 4.5005
R131 avdd.n2 avdd.n1 4.5005
R132 avdd.n125 avdd.n124 4.5005
R133 avdd.n36 avdd.n35 4.5005
R134 avdd.n37 avdd.n19 4.5005
R135 avdd.n39 avdd.n38 4.5005
R136 avdd.n9 avdd.n8 4.5005
R137 avdd.n52 avdd.n51 4.5005
R138 avdd.n53 avdd.n7 4.5005
R139 avdd.n119 avdd.n118 4.5005
R140 avdd.n21 avdd.n20 4.5005
R141 avdd.n85 avdd.n84 4.5005
R142 avdd.n69 avdd.n68 4.5005
R143 avdd.n98 avdd.n97 4.5005
R144 avdd.n99 avdd.n67 4.5005
R145 avdd.n101 avdd.n100 4.5005
R146 avdd.n56 avdd.n55 4.5005
R147 avdd.n115 avdd.n114 4.5005
R148 avdd.n83 avdd.n79 4.5005
R149 avdd.n90 avdd.n89 4.5005
R150 avdd.n91 avdd.n73 4.5005
R151 avdd.n93 avdd.n92 4.5005
R152 avdd.n63 avdd.n62 4.5005
R153 avdd.n106 avdd.n105 4.5005
R154 avdd.n107 avdd.n61 4.5005
R155 avdd.n109 avdd.n108 4.5005
R156 avdd.n75 avdd.n74 4.5005
R157 avdd.n123 avdd.n122 1.33893
R158 avdd.n26 avdd.n22 1.33893
R159 avdd.n113 avdd.n112 1.33893
R160 avdd.n80 avdd.n76 1.33893
R161 avdd.n28 avdd.n27 0.9005
R162 avdd.n82 avdd.n81 0.9005
R163 avdd.n58 avdd.n54 0.9005
R164 avdd.n4 avdd.n0 0.9005
R165 avdd.n116 avdd.n54 0.454413
R166 avdd.n117 avdd.n0 0.454413
R167 avdd.n126 avdd.n0 0.454413
R168 avdd.n117 avdd.n116 0.427022
R169 avdd.n35 avdd.n21 0.1445
R170 avdd.n35 avdd.n19 0.1445
R171 avdd.n39 avdd.n19 0.1445
R172 avdd.n39 avdd.n9 0.1445
R173 avdd.n51 avdd.n9 0.1445
R174 avdd.n51 avdd.n7 0.1445
R175 avdd.n119 avdd.n7 0.1445
R176 avdd.n31 avdd.n25 0.1445
R177 avdd.n31 avdd.n15 0.1445
R178 avdd.n43 avdd.n15 0.1445
R179 avdd.n43 avdd.n13 0.1445
R180 avdd.n47 avdd.n13 0.1445
R181 avdd.n47 avdd.n2 0.1445
R182 avdd.n124 avdd.n2 0.1445
R183 avdd.n30 avdd.n29 0.1445
R184 avdd.n30 avdd.n14 0.1445
R185 avdd.n44 avdd.n14 0.1445
R186 avdd.n45 avdd.n44 0.1445
R187 avdd.n46 avdd.n45 0.1445
R188 avdd.n46 avdd.n1 0.1445
R189 avdd.n125 avdd.n1 0.1445
R190 avdd.n36 avdd.n20 0.1445
R191 avdd.n37 avdd.n36 0.1445
R192 avdd.n38 avdd.n37 0.1445
R193 avdd.n38 avdd.n8 0.1445
R194 avdd.n52 avdd.n8 0.1445
R195 avdd.n53 avdd.n52 0.1445
R196 avdd.n118 avdd.n53 0.1445
R197 avdd.n89 avdd.n75 0.1445
R198 avdd.n89 avdd.n73 0.1445
R199 avdd.n93 avdd.n73 0.1445
R200 avdd.n93 avdd.n63 0.1445
R201 avdd.n105 avdd.n63 0.1445
R202 avdd.n105 avdd.n61 0.1445
R203 avdd.n109 avdd.n61 0.1445
R204 avdd.n85 avdd.n79 0.1445
R205 avdd.n85 avdd.n69 0.1445
R206 avdd.n97 avdd.n69 0.1445
R207 avdd.n97 avdd.n67 0.1445
R208 avdd.n101 avdd.n67 0.1445
R209 avdd.n101 avdd.n56 0.1445
R210 avdd.n114 avdd.n56 0.1445
R211 avdd.n84 avdd.n83 0.1445
R212 avdd.n84 avdd.n68 0.1445
R213 avdd.n98 avdd.n68 0.1445
R214 avdd.n99 avdd.n98 0.1445
R215 avdd.n100 avdd.n99 0.1445
R216 avdd.n100 avdd.n55 0.1445
R217 avdd.n115 avdd.n55 0.1445
R218 avdd.n90 avdd.n74 0.1445
R219 avdd.n91 avdd.n90 0.1445
R220 avdd.n92 avdd.n91 0.1445
R221 avdd.n92 avdd.n62 0.1445
R222 avdd.n106 avdd.n62 0.1445
R223 avdd.n107 avdd.n106 0.1445
R224 avdd.n108 avdd.n107 0.1445
C0 M0_0/a_500_n131# avdd 0.81336f
C1 M0_0/a_500_n131# ifwd 0.03808f
C2 avdd i_SUM 0.04685f
C3 i_SUM ifwd 0.01909f
C4 M0_0/a_500_n131# i_SUM 0.35509f
C5 avdd ifwd 0.38336f
C6 avdd.n0 VSUBS 0.00837f
C7 avdd.n1 VSUBS 0.00313f
C8 avdd.n2 VSUBS 0.00313f
C9 avdd.n3 VSUBS 0.00226f
C10 avdd.n4 VSUBS 0.05537f
C11 avdd.n5 VSUBS 0.03508f
C12 avdd.n6 VSUBS 0.00226f
C13 avdd.n7 VSUBS 0.00313f
C14 avdd.n8 VSUBS 0.00313f
C15 avdd.n9 VSUBS 0.00313f
C16 avdd.n10 VSUBS 0.00226f
C17 avdd.n11 VSUBS 0.03508f
C18 avdd.n12 VSUBS 0.00226f
C19 avdd.n13 VSUBS 0.00313f
C20 avdd.n14 VSUBS 0.00313f
C21 avdd.n15 VSUBS 0.00313f
C22 avdd.n16 VSUBS 0.00226f
C23 avdd.n17 VSUBS 0.03508f
C24 avdd.n18 VSUBS 0.00226f
C25 avdd.n19 VSUBS 0.00313f
C26 avdd.n20 VSUBS 0.00738f
C27 avdd.n21 VSUBS 0.00254f
C28 avdd.n22 VSUBS 0.00615f
C29 avdd.n23 VSUBS 0.04339f
C30 avdd.n24 VSUBS 0.00615f
C31 avdd.n25 VSUBS 0.00254f
C32 avdd.n27 VSUBS 0.05537f
C33 avdd.n28 VSUBS 0.0183f
C34 avdd.n29 VSUBS 0.00738f
C35 avdd.n30 VSUBS 0.00313f
C36 avdd.n31 VSUBS 0.00313f
C37 avdd.n32 VSUBS 0.00226f
C38 avdd.n33 VSUBS 0.03508f
C39 avdd.n34 VSUBS 0.00226f
C40 avdd.n35 VSUBS 0.00313f
C41 avdd.n36 VSUBS 0.00313f
C42 avdd.n37 VSUBS 0.00313f
C43 avdd.n38 VSUBS 0.00313f
C44 avdd.n39 VSUBS 0.00313f
C45 avdd.n40 VSUBS 0.00226f
C46 avdd.n41 VSUBS 0.03508f
C47 avdd.n42 VSUBS 0.00226f
C48 avdd.n43 VSUBS 0.00313f
C49 avdd.n44 VSUBS 0.00313f
C50 avdd.n45 VSUBS 0.00313f
C51 avdd.n46 VSUBS 0.00313f
C52 avdd.n47 VSUBS 0.00313f
C53 avdd.n48 VSUBS 0.00226f
C54 avdd.n49 VSUBS 0.03508f
C55 avdd.n50 VSUBS 0.00226f
C56 avdd.n51 VSUBS 0.00313f
C57 avdd.n52 VSUBS 0.00313f
C58 avdd.n53 VSUBS 0.00313f
C59 avdd.n54 VSUBS 0.01334f
C60 avdd.n55 VSUBS 0.00313f
C61 avdd.n56 VSUBS 0.00313f
C62 avdd.n57 VSUBS 0.00226f
C63 avdd.n58 VSUBS 0.05537f
C64 avdd.n59 VSUBS 0.03508f
C65 avdd.n60 VSUBS 0.00226f
C66 avdd.n61 VSUBS 0.00313f
C67 avdd.n62 VSUBS 0.00313f
C68 avdd.n63 VSUBS 0.00313f
C69 avdd.n64 VSUBS 0.00226f
C70 avdd.n65 VSUBS 0.03508f
C71 avdd.n66 VSUBS 0.00226f
C72 avdd.n67 VSUBS 0.00313f
C73 avdd.n68 VSUBS 0.00313f
C74 avdd.n69 VSUBS 0.00313f
C75 avdd.n70 VSUBS 0.00226f
C76 avdd.n71 VSUBS 0.03508f
C77 avdd.n72 VSUBS 0.00226f
C78 avdd.n73 VSUBS 0.00313f
C79 avdd.n74 VSUBS 0.00738f
C80 avdd.n75 VSUBS 0.00254f
C81 avdd.n76 VSUBS 0.00615f
C82 avdd.n77 VSUBS 0.04339f
C83 avdd.n78 VSUBS 0.00615f
C84 avdd.n79 VSUBS 0.00254f
C85 avdd.n81 VSUBS 0.05537f
C86 avdd.n82 VSUBS 0.0183f
C87 avdd.n83 VSUBS 0.00738f
C88 avdd.n84 VSUBS 0.00313f
C89 avdd.n85 VSUBS 0.00313f
C90 avdd.n86 VSUBS 0.00226f
C91 avdd.n87 VSUBS 0.03508f
C92 avdd.n88 VSUBS 0.00226f
C93 avdd.n89 VSUBS 0.00313f
C94 avdd.n90 VSUBS 0.00313f
C95 avdd.n91 VSUBS 0.00313f
C96 avdd.n92 VSUBS 0.00313f
C97 avdd.n93 VSUBS 0.00313f
C98 avdd.n94 VSUBS 0.00226f
C99 avdd.n95 VSUBS 0.03508f
C100 avdd.n96 VSUBS 0.00226f
C101 avdd.n97 VSUBS 0.00313f
C102 avdd.n98 VSUBS 0.00313f
C103 avdd.n99 VSUBS 0.00313f
C104 avdd.n100 VSUBS 0.00313f
C105 avdd.n101 VSUBS 0.00313f
C106 avdd.n102 VSUBS 0.00226f
C107 avdd.n103 VSUBS 0.03508f
C108 avdd.n104 VSUBS 0.00226f
C109 avdd.n105 VSUBS 0.00313f
C110 avdd.n106 VSUBS 0.00313f
C111 avdd.n107 VSUBS 0.00313f
C112 avdd.n108 VSUBS 0.00738f
C113 avdd.n109 VSUBS 0.00254f
C114 avdd.n110 VSUBS 0.00615f
C115 avdd.n111 VSUBS 0.04339f
C116 avdd.n113 VSUBS 0.00615f
C117 avdd.n114 VSUBS 0.00254f
C118 avdd.n115 VSUBS 0.00691f
C119 avdd.n116 VSUBS 0.00854f
C120 avdd.n117 VSUBS 0.00854f
C121 avdd.n118 VSUBS 0.00691f
C122 avdd.n119 VSUBS 0.00254f
C123 avdd.n120 VSUBS 0.00615f
C124 avdd.n121 VSUBS 0.04339f
C125 avdd.n123 VSUBS 0.00615f
C126 avdd.n124 VSUBS 0.00254f
C127 avdd.n125 VSUBS 0.00691f
C128 avdd.n126 VSUBS 0.01562f
C129 ifwd.n0 VSUBS 0.13362f
C130 ifwd.n1 VSUBS 0.01628f
C131 M0_0/a_500_n131# VSUBS -0.71714f
C132 i_SUM VSUBS 0.11006f
C133 ifwd VSUBS -0.32811f
C134 avdd VSUBS -1.22132f
.ends
