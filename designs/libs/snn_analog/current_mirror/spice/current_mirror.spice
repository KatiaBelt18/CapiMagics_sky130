* NGSPICE file created from current_mirror.ext - technology: sky130A

.subckt M3 w_n637_n635# a_n377_n200# a_n299_n396# a_n199_n200# VSUBS
X0 a_n199_n200# a_n299_n396# a_n377_n200# w_n637_n635# sky130_fd_pr__pfet_01v8 ad=0.33 pd=2.33 as=0.78 ps=4.78 w=2 l=0.5
X1 a_n377_n200# a_n299_n396# a_n199_n200# w_n637_n635# sky130_fd_pr__pfet_01v8 ad=0.78 pd=4.78 as=0.33 ps=2.33 w=2 l=0.5
X2 a_n199_n200# a_n299_n396# a_n377_n200# w_n637_n635# sky130_fd_pr__pfet_01v8 ad=0.33 pd=2.33 as=0.33 ps=2.33 w=2 l=0.5
X3 a_n377_n200# a_n299_n396# a_n199_n200# w_n637_n635# sky130_fd_pr__pfet_01v8 ad=0.33 pd=2.33 as=0.33 ps=2.33 w=2 l=0.5
C0 w_n637_n635# a_n377_n200# 0.47542f
C1 a_n299_n396# a_n199_n200# 0.3865f
C2 a_n299_n396# w_n637_n635# 1.24409f
C3 a_n299_n396# a_n377_n200# 0.46594f
C4 w_n637_n635# a_n199_n200# 0.46013f
C5 a_n377_n200# a_n199_n200# 1.39122f
C6 a_n199_n200# VSUBS 0.01121f
C7 a_n377_n200# VSUBS 0.10592f
C8 a_n299_n396# VSUBS 0.09789f
C9 w_n637_n635# VSUBS 5.78208f
.ends

.subckt M1 a_n167_n200# a_n33_n200# a_n89_n396# a_n381_n589#
X0 a_n33_n200# a_n89_n396# a_n167_n200# a_n381_n589# sky130_fd_pr__nfet_01v8 ad=0.33 pd=2.33 as=0.78 ps=4.78 w=2 l=0.28
X1 a_n167_n200# a_n89_n396# a_n33_n200# a_n381_n589# sky130_fd_pr__nfet_01v8 ad=0.78 pd=4.78 as=0.33 ps=2.33 w=2 l=0.28
C0 a_n89_n396# a_n33_n200# 0.13519f
C1 a_n89_n396# a_n167_n200# 0.13502f
C2 a_n167_n200# a_n33_n200# 0.85473f
C3 a_n33_n200# a_n381_n589# 0.20631f
C4 a_n167_n200# a_n381_n589# 0.50521f
C5 a_n89_n396# a_n381_n589# 0.51868f
.ends

.subckt M4 w_n388_n595# a_n50_n358# a_n128_n160# a_50_n160# VSUBS
X0 a_50_n160# a_n50_n358# a_n128_n160# w_n388_n595# sky130_fd_pr__pfet_01v8 ad=0.624 pd=3.98 as=0.624 ps=3.98 w=1.6 l=0.5
C0 w_n388_n595# a_n128_n160# 0.19543f
C1 a_n50_n358# a_50_n160# 0.0694f
C2 w_n388_n595# a_50_n160# 0.32873f
C3 w_n388_n595# a_n50_n358# 0.34447f
C4 a_n128_n160# a_50_n160# 0.35618f
C5 a_n50_n358# a_n128_n160# 0.09433f
C6 a_50_n160# VSUBS 0.05231f
C7 a_n128_n160# VSUBS 0.05176f
C8 a_n50_n358# VSUBS 0.04917f
C9 w_n388_n595# VSUBS 3.39219f
.ends

.subckt M2 a_n833_n396# a_n33_n200# a_n1125_n589# a_n911_n200#
X0 a_n33_n200# a_n833_n396# a_n911_n200# a_n1125_n589# sky130_fd_pr__nfet_01v8 ad=0.33 pd=2.33 as=0.78 ps=4.78 w=2 l=4
X1 a_n911_n200# a_n833_n396# a_n33_n200# a_n1125_n589# sky130_fd_pr__nfet_01v8 ad=0.78 pd=4.78 as=0.33 ps=2.33 w=2 l=4
C0 a_n833_n396# a_n33_n200# 0.41343f
C1 a_n833_n396# a_n911_n200# 0.78452f
C2 a_n911_n200# a_n33_n200# 1.1534f
C3 a_n33_n200# a_n1125_n589# 0.79907f
C4 a_n911_n200# a_n1125_n589# 0.6075f
C5 a_n833_n396# a_n1125_n589# 3.21884f
.ends

.subckt current_mirror avss avdd A B
XM3_0 avdd avdd B B avss M3
XM1_0 avss A A avss M1
XM4_0 avdd A avdd A avss M4
XM2_0 A B avss avss M2
R0 B.n6 B.n2 206.976
R1 B.n6 B.n5 206.262
R2 B.n13 B.n12 195.948
R3 B.n17 B.n8 174.966
R4 B.n16 B.n9 174.966
R5 B.n11 B.n10 174.966
R6 B.n15 B.n14 161.3
R7 B.n16 B.n7 161.3
R8 B.n18 B.n17 161.3
R9 B.n14 B.n13 70.4033
R10 B.n17 B.n16 48.2005
R11 B.n16 B.n15 24.1005
R12 B.n15 B.n11 24.1005
R13 B.n13 B.n11 20.9576
R14 B.n2 B.n0 16.253
R15 B.n2 B.n1 16.253
R16 B.n5 B.n3 16.253
R17 B.n5 B.n4 16.253
R18 B B.n19 10.7478
R19 B.n19 B.n6 7.50856
R20 B.n19 B.n18 5.69179
R21 B.n18 B.n7 0.189894
R22 B.n14 B.n7 0.189894
R23 A.n5 A.n3 328.584
R24 A.n5 A.n4 328.584
R25 A.n2 A.n1 323.36
R26 A.n2 A.n0 281.209
R27 A.n9 A.n5 168.071
R28 A.n9 A.n8 111.751
R29 A.n13 A.n11 45.9075
R30 A.n13 A.n12 44.4597
R31 A A.n10 10.6037
R32 A.n8 A.n6 9.9005
R33 A.n8 A.n7 9.9005
R34 A A.n13 9.57781
R35 A.n10 A.n2 0.782697
R36 A.n10 A.n9 0.598985
R37 avdd.n80 avdd.n9 403.902
R38 avdd.n77 avdd.n13 403.902
R39 avdd.n57 avdd.n32 403.902
R40 avdd.n54 avdd.n33 403.902
R41 avdd.n121 avdd.n109 361.464
R42 avdd.n193 avdd.n5 361.464
R43 avdd.n144 avdd.n111 361.464
R44 avdd.n169 avdd.n93 361.464
R45 avdd.n81 avdd.n80 185
R46 avdd.n80 avdd.n79 185
R47 avdd.n10 avdd.n8 185
R48 avdd.n15 avdd.n13 185
R49 avdd.n36 avdd.n32 185
R50 avdd.n37 avdd.n35 185
R51 avdd.n54 avdd.n53 185
R52 avdd.n55 avdd.n54 185
R53 avdd.n9 avdd.n6 185
R54 avdd.n78 avdd.n9 185
R55 avdd.n39 avdd.n38 185
R56 avdd.n38 avdd.n12 185
R57 avdd.n40 avdd.n19 185
R58 avdd.n72 avdd.n19 185
R59 avdd.n41 avdd.n20 185
R60 avdd.n71 avdd.n20 185
R61 avdd.n42 avdd.n21 185
R62 avdd.n70 avdd.n21 185
R63 avdd.n44 avdd.n43 185
R64 avdd.n43 avdd.n22 185
R65 avdd.n45 avdd.n26 185
R66 avdd.n64 avdd.n26 185
R67 avdd.n46 avdd.n27 185
R68 avdd.n63 avdd.n27 185
R69 avdd.n47 avdd.n28 185
R70 avdd.n62 avdd.n28 185
R71 avdd.n49 avdd.n48 185
R72 avdd.n48 avdd.n29 185
R73 avdd.n50 avdd.n33 185
R74 avdd.n56 avdd.n33 185
R75 avdd.n58 avdd.n57 185
R76 avdd.n57 avdd.n56 185
R77 avdd.n59 avdd.n30 185
R78 avdd.n30 avdd.n29 185
R79 avdd.n61 avdd.n60 185
R80 avdd.n62 avdd.n61 185
R81 avdd.n25 avdd.n24 185
R82 avdd.n63 avdd.n25 185
R83 avdd.n66 avdd.n65 185
R84 avdd.n65 avdd.n64 185
R85 avdd.n67 avdd.n23 185
R86 avdd.n23 avdd.n22 185
R87 avdd.n69 avdd.n68 185
R88 avdd.n70 avdd.n69 185
R89 avdd.n18 avdd.n17 185
R90 avdd.n71 avdd.n18 185
R91 avdd.n74 avdd.n73 185
R92 avdd.n73 avdd.n72 185
R93 avdd.n75 avdd.n14 185
R94 avdd.n14 avdd.n12 185
R95 avdd.n77 avdd.n76 185
R96 avdd.n78 avdd.n77 185
R97 avdd.n109 avdd.n108 185
R98 avdd.n110 avdd.n109 185
R99 avdd.n152 avdd.n151 185
R100 avdd.n151 avdd.n150 185
R101 avdd.n106 avdd.n104 185
R102 avdd.n104 avdd.n103 185
R103 avdd.n157 avdd.n156 185
R104 avdd.n158 avdd.n157 185
R105 avdd.n105 avdd.n2 185
R106 avdd.n105 avdd.n97 185
R107 avdd.n199 avdd.n3 185
R108 avdd.n166 avdd.n3 185
R109 avdd.n198 avdd.n4 185
R110 avdd.n167 avdd.n4 185
R111 avdd.n197 avdd.n5 185
R112 avdd.n168 avdd.n5 185
R113 avdd.n170 avdd.n169 185
R114 avdd.n169 avdd.n168 185
R115 avdd.n96 avdd.n95 185
R116 avdd.n167 avdd.n96 185
R117 avdd.n165 avdd.n164 185
R118 avdd.n166 avdd.n165 185
R119 avdd.n99 avdd.n98 185
R120 avdd.n98 avdd.n97 185
R121 avdd.n160 avdd.n159 185
R122 avdd.n159 avdd.n158 185
R123 avdd.n102 avdd.n101 185
R124 avdd.n103 avdd.n102 185
R125 avdd.n149 avdd.n148 185
R126 avdd.n150 avdd.n149 185
R127 avdd.n112 avdd.n111 185
R128 avdd.n111 avdd.n110 185
R129 avdd.n172 avdd.n93 185
R130 avdd.n93 avdd.n85 185
R131 avdd.n174 avdd.n173 185
R132 avdd.n176 avdd.n91 185
R133 avdd.n178 avdd.n177 185
R134 avdd.n179 avdd.n90 185
R135 avdd.n181 avdd.n180 185
R136 avdd.n183 avdd.n88 185
R137 avdd.n185 avdd.n184 185
R138 avdd.n186 avdd.n87 185
R139 avdd.n188 avdd.n187 185
R140 avdd.n190 avdd.n86 185
R141 avdd.n191 avdd.n84 185
R142 avdd.n194 avdd.n193 185
R143 avdd.n122 avdd.n121 185
R144 avdd.n124 avdd.n123 185
R145 avdd.n126 avdd.n125 185
R146 avdd.n128 avdd.n127 185
R147 avdd.n130 avdd.n129 185
R148 avdd.n132 avdd.n131 185
R149 avdd.n134 avdd.n133 185
R150 avdd.n136 avdd.n135 185
R151 avdd.n138 avdd.n137 185
R152 avdd.n139 avdd.n120 185
R153 avdd.n141 avdd.n140 185
R154 avdd.n114 avdd.n113 185
R155 avdd.n145 avdd.n144 185
R156 avdd.n144 avdd.n143 185
R157 avdd.n79 avdd.n78 173.84
R158 avdd.n56 avdd.n55 173.84
R159 avdd.n80 avdd.n10 146.341
R160 avdd.n54 avdd.n35 146.341
R161 avdd.n151 avdd.n109 146.341
R162 avdd.n151 avdd.n104 146.341
R163 avdd.n157 avdd.n104 146.341
R164 avdd.n157 avdd.n105 146.341
R165 avdd.n105 avdd.n3 146.341
R166 avdd.n4 avdd.n3 146.341
R167 avdd.n5 avdd.n4 146.341
R168 avdd.n149 avdd.n111 146.341
R169 avdd.n149 avdd.n102 146.341
R170 avdd.n159 avdd.n102 146.341
R171 avdd.n159 avdd.n98 146.341
R172 avdd.n165 avdd.n98 146.341
R173 avdd.n165 avdd.n96 146.341
R174 avdd.n169 avdd.n96 146.341
R175 avdd.n143 avdd.n110 130.157
R176 avdd.n168 avdd.n85 130.157
R177 avdd.n77 avdd.n14 99.5127
R178 avdd.n73 avdd.n14 99.5127
R179 avdd.n73 avdd.n18 99.5127
R180 avdd.n69 avdd.n18 99.5127
R181 avdd.n69 avdd.n23 99.5127
R182 avdd.n65 avdd.n23 99.5127
R183 avdd.n65 avdd.n25 99.5127
R184 avdd.n61 avdd.n25 99.5127
R185 avdd.n61 avdd.n30 99.5127
R186 avdd.n57 avdd.n30 99.5127
R187 avdd.n38 avdd.n9 99.5127
R188 avdd.n38 avdd.n19 99.5127
R189 avdd.n20 avdd.n19 99.5127
R190 avdd.n21 avdd.n20 99.5127
R191 avdd.n43 avdd.n21 99.5127
R192 avdd.n43 avdd.n26 99.5127
R193 avdd.n27 avdd.n26 99.5127
R194 avdd.n28 avdd.n27 99.5127
R195 avdd.n48 avdd.n28 99.5127
R196 avdd.n48 avdd.n33 99.5127
R197 avdd.n125 avdd.n124 99.5127
R198 avdd.n129 avdd.n128 99.5127
R199 avdd.n133 avdd.n132 99.5127
R200 avdd.n137 avdd.n136 99.5127
R201 avdd.n141 avdd.n120 99.5127
R202 avdd.n144 avdd.n114 99.5127
R203 avdd.n191 avdd.n190 99.5127
R204 avdd.n188 avdd.n87 99.5127
R205 avdd.n184 avdd.n183 99.5127
R206 avdd.n181 avdd.n90 99.5127
R207 avdd.n177 avdd.n176 99.5127
R208 avdd.n174 avdd.n93 99.5127
R209 avdd.n78 avdd.n12 83.2479
R210 avdd.n72 avdd.n12 83.2479
R211 avdd.n72 avdd.n71 83.2479
R212 avdd.n71 avdd.n70 83.2479
R213 avdd.n70 avdd.n22 83.2479
R214 avdd.n64 avdd.n22 83.2479
R215 avdd.n64 avdd.n63 83.2479
R216 avdd.n63 avdd.n62 83.2479
R217 avdd.n62 avdd.n29 83.2479
R218 avdd.n56 avdd.n29 83.2479
R219 avdd.n150 avdd.n110 74.8036
R220 avdd.n150 avdd.n103 74.8036
R221 avdd.n158 avdd.n103 74.8036
R222 avdd.n158 avdd.n97 74.8036
R223 avdd.n166 avdd.n97 74.8036
R224 avdd.n167 avdd.n166 74.8036
R225 avdd.n168 avdd.n167 74.8036
R226 avdd.n175 avdd.n85 72.8958
R227 avdd.n92 avdd.n85 72.8958
R228 avdd.n182 avdd.n85 72.8958
R229 avdd.n89 avdd.n85 72.8958
R230 avdd.n189 avdd.n85 72.8958
R231 avdd.n192 avdd.n85 72.8958
R232 avdd.n143 avdd.n115 72.8958
R233 avdd.n143 avdd.n116 72.8958
R234 avdd.n143 avdd.n117 72.8958
R235 avdd.n143 avdd.n118 72.8958
R236 avdd.n143 avdd.n119 72.8958
R237 avdd.n143 avdd.n142 72.8958
R238 avdd.n79 avdd.n11 66.2847
R239 avdd.n55 avdd.n34 66.2847
R240 avdd.n13 avdd.n11 52.4337
R241 avdd.n11 avdd.n10 52.4337
R242 avdd.n34 avdd.n32 52.4337
R243 avdd.n35 avdd.n34 52.4337
R244 avdd.n121 avdd.n115 39.2114
R245 avdd.n125 avdd.n116 39.2114
R246 avdd.n129 avdd.n117 39.2114
R247 avdd.n133 avdd.n118 39.2114
R248 avdd.n137 avdd.n119 39.2114
R249 avdd.n142 avdd.n141 39.2114
R250 avdd.n192 avdd.n191 39.2114
R251 avdd.n189 avdd.n188 39.2114
R252 avdd.n184 avdd.n89 39.2114
R253 avdd.n182 avdd.n181 39.2114
R254 avdd.n177 avdd.n92 39.2114
R255 avdd.n175 avdd.n174 39.2114
R256 avdd.n176 avdd.n175 39.2114
R257 avdd.n92 avdd.n90 39.2114
R258 avdd.n183 avdd.n182 39.2114
R259 avdd.n89 avdd.n87 39.2114
R260 avdd.n190 avdd.n189 39.2114
R261 avdd.n193 avdd.n192 39.2114
R262 avdd.n124 avdd.n115 39.2114
R263 avdd.n128 avdd.n116 39.2114
R264 avdd.n132 avdd.n117 39.2114
R265 avdd.n136 avdd.n118 39.2114
R266 avdd.n120 avdd.n119 39.2114
R267 avdd.n142 avdd.n114 39.2114
R268 avdd.n52 avdd.n50 31.7331
R269 avdd.n58 avdd.n31 31.7331
R270 avdd.n76 avdd.n16 31.56
R271 avdd.n83 avdd.n6 31.5289
R272 avdd.n172 avdd.n171 27.3609
R273 avdd.n146 avdd.n145 27.3609
R274 avdd.n122 avdd.n107 27.1916
R275 avdd.n195 avdd.n194 27.1581
R276 avdd.n53 avdd.n37 19.3944
R277 avdd.n37 avdd.n36 19.3944
R278 avdd.n81 avdd.n8 19.3944
R279 avdd.n15 avdd.n8 19.3944
R280 avdd.n148 avdd.n112 19.3944
R281 avdd.n148 avdd.n101 19.3944
R282 avdd.n160 avdd.n101 19.3944
R283 avdd.n160 avdd.n99 19.3944
R284 avdd.n164 avdd.n99 19.3944
R285 avdd.n164 avdd.n95 19.3944
R286 avdd.n170 avdd.n95 19.3944
R287 avdd.n152 avdd.n108 19.3944
R288 avdd.n152 avdd.n106 19.3944
R289 avdd.n156 avdd.n106 19.3944
R290 avdd.n156 avdd.n2 19.3944
R291 avdd.n199 avdd.n2 19.3944
R292 avdd.n199 avdd.n198 19.3944
R293 avdd.n198 avdd.n197 19.3944
R294 avdd avdd.n201 11.3205
R295 avdd.n40 avdd.n39 10.6151
R296 avdd.n126 avdd.n123 10.6151
R297 avdd.n39 avdd.n6 10.6151
R298 avdd.n41 avdd.n40 10.6151
R299 avdd.n42 avdd.n41 10.6151
R300 avdd.n44 avdd.n42 10.6151
R301 avdd.n45 avdd.n44 10.6151
R302 avdd.n46 avdd.n45 10.6151
R303 avdd.n47 avdd.n46 10.6151
R304 avdd.n49 avdd.n47 10.6151
R305 avdd.n50 avdd.n49 10.6151
R306 avdd.n76 avdd.n75 10.6151
R307 avdd.n75 avdd.n74 10.6151
R308 avdd.n74 avdd.n17 10.6151
R309 avdd.n68 avdd.n17 10.6151
R310 avdd.n68 avdd.n67 10.6151
R311 avdd.n67 avdd.n66 10.6151
R312 avdd.n66 avdd.n24 10.6151
R313 avdd.n60 avdd.n24 10.6151
R314 avdd.n60 avdd.n59 10.6151
R315 avdd.n59 avdd.n58 10.6151
R316 avdd.n194 avdd.n84 10.6151
R317 avdd.n86 avdd.n84 10.6151
R318 avdd.n187 avdd.n86 10.6151
R319 avdd.n187 avdd.n186 10.6151
R320 avdd.n186 avdd.n185 10.6151
R321 avdd.n185 avdd.n88 10.6151
R322 avdd.n180 avdd.n88 10.6151
R323 avdd.n180 avdd.n179 10.6151
R324 avdd.n179 avdd.n178 10.6151
R325 avdd.n178 avdd.n91 10.6151
R326 avdd.n173 avdd.n91 10.6151
R327 avdd.n173 avdd.n172 10.6151
R328 avdd.n123 avdd.n122 10.6151
R329 avdd.n127 avdd.n126 10.6151
R330 avdd.n130 avdd.n127 10.6151
R331 avdd.n131 avdd.n130 10.6151
R332 avdd.n134 avdd.n131 10.6151
R333 avdd.n135 avdd.n134 10.6151
R334 avdd.n138 avdd.n135 10.6151
R335 avdd.n139 avdd.n138 10.6151
R336 avdd.n140 avdd.n139 10.6151
R337 avdd.n140 avdd.n113 10.6151
R338 avdd.n145 avdd.n113 10.6151
R339 avdd.n51 avdd.n37 9.3005
R340 avdd.n36 avdd.n31 9.3005
R341 avdd.n53 avdd.n52 9.3005
R342 avdd.n82 avdd.n81 9.3005
R343 avdd.n8 avdd.n7 9.3005
R344 avdd.n16 avdd.n15 9.3005
R345 avdd.n148 avdd.n147 9.3005
R346 avdd.n101 avdd.n100 9.3005
R347 avdd.n161 avdd.n160 9.3005
R348 avdd.n162 avdd.n99 9.3005
R349 avdd.n164 avdd.n163 9.3005
R350 avdd.n95 avdd.n94 9.3005
R351 avdd.n171 avdd.n170 9.3005
R352 avdd.n146 avdd.n112 9.3005
R353 avdd.n108 avdd.n107 9.3005
R354 avdd.n153 avdd.n152 9.3005
R355 avdd.n154 avdd.n106 9.3005
R356 avdd.n156 avdd.n155 9.3005
R357 avdd.n2 avdd.n0 9.3005
R358 avdd.n200 avdd.n199 9.3005
R359 avdd.n198 avdd.n1 9.3005
R360 avdd.n197 avdd.n196 9.3005
R361 avdd.n195 avdd.n83 1.14585
R362 avdd.n52 avdd.n51 0.152939
R363 avdd.n51 avdd.n31 0.152939
R364 avdd.n147 avdd.n146 0.152939
R365 avdd.n147 avdd.n100 0.152939
R366 avdd.n161 avdd.n100 0.152939
R367 avdd.n162 avdd.n161 0.152939
R368 avdd.n163 avdd.n162 0.152939
R369 avdd.n163 avdd.n94 0.152939
R370 avdd.n171 avdd.n94 0.152939
R371 avdd.n196 avdd.n195 0.0339507
R372 avdd.n83 avdd.n82 0.0316918
R373 avdd.n153 avdd.n107 0.0256509
R374 avdd.n154 avdd.n153 0.0256509
R375 avdd.n155 avdd.n154 0.0256509
R376 avdd.n155 avdd.n0 0.0256509
R377 avdd.n200 avdd.n1 0.0256509
R378 avdd.n196 avdd.n1 0.0256509
R379 avdd.n82 avdd.n7 0.0237775
R380 avdd.n16 avdd.n7 0.0237775
R381 avdd.n201 avdd.n200 0.0186087
R382 avdd.n201 avdd.n0 0.00754225
R383 avss.n211 avss.n210 61197.5
R384 avss.n26 avss.n8 1559.09
R385 avss.n259 avss.n28 694.306
R386 avss.n249 avss.n62 694.306
R387 avss.n225 avss.n213 694.306
R388 avss.n261 avss.n24 694.306
R389 avss.n139 avss.n138 679.89
R390 avss.n290 avss.n10 679.89
R391 avss.n135 avss.n66 679.89
R392 avss.n292 avss.n6 679.89
R393 avss.n59 avss.n28 585
R394 avss.n58 avss.n57 585
R395 avss.n55 avss.n31 585
R396 avss.n53 avss.n52 585
R397 avss.n51 avss.n32 585
R398 avss.n50 avss.n49 585
R399 avss.n47 avss.n33 585
R400 avss.n45 avss.n44 585
R401 avss.n43 avss.n34 585
R402 avss.n42 avss.n41 585
R403 avss.n39 avss.n35 585
R404 avss.n37 avss.n36 585
R405 avss.n24 avss.n21 585
R406 avss.n26 avss.n24 585
R407 avss.n226 avss.n225 585
R408 avss.n228 avss.n227 585
R409 avss.n230 avss.n229 585
R410 avss.n232 avss.n231 585
R411 avss.n234 avss.n233 585
R412 avss.n236 avss.n235 585
R413 avss.n238 avss.n237 585
R414 avss.n240 avss.n239 585
R415 avss.n242 avss.n241 585
R416 avss.n244 avss.n243 585
R417 avss.n246 avss.n245 585
R418 avss.n247 avss.n220 585
R419 avss.n249 avss.n248 585
R420 avss.n250 avss.n249 585
R421 avss.n223 avss.n213 585
R422 avss.n251 avss.n213 585
R423 avss.n222 avss.n212 585
R424 avss.n252 avss.n212 585
R425 avss.n25 avss.n23 585
R426 avss.n27 avss.n25 585
R427 avss.n262 avss.n261 585
R428 avss.n261 avss.n260 585
R429 avss.n259 avss.n258 585
R430 avss.n260 avss.n259 585
R431 avss.n30 avss.n29 585
R432 avss.n29 avss.n27 585
R433 avss.n254 avss.n253 585
R434 avss.n253 avss.n252 585
R435 avss.n62 avss.n61 585
R436 avss.n251 avss.n62 585
R437 avss.n290 avss.n289 585
R438 avss.n291 avss.n290 585
R439 avss.n11 avss.n9 585
R440 avss.n9 avss.n7 585
R441 avss.n181 avss.n180 585
R442 avss.n182 avss.n181 585
R443 avss.n89 avss.n88 585
R444 avss.n183 avss.n88 585
R445 avss.n176 avss.n87 585
R446 avss.n184 avss.n87 585
R447 avss.n175 avss.n174 585
R448 avss.n174 avss.n86 585
R449 avss.n173 avss.n91 585
R450 avss.n173 avss.n172 585
R451 avss.n96 avss.n92 585
R452 avss.n171 avss.n92 585
R453 avss.n168 avss.n167 585
R454 avss.n170 avss.n168 585
R455 avss.n95 avss.n94 585
R456 avss.n94 avss.n93 585
R457 avss.n161 avss.n160 585
R458 avss.n160 avss.n159 585
R459 avss.n99 avss.n98 585
R460 avss.n158 avss.n99 585
R461 avss.n155 avss.n154 585
R462 avss.n157 avss.n155 585
R463 avss.n102 avss.n101 585
R464 avss.n101 avss.n100 585
R465 avss.n150 avss.n149 585
R466 avss.n149 avss.n148 585
R467 avss.n146 avss.n104 585
R468 avss.n147 avss.n146 585
R469 avss.n145 avss.n144 585
R470 avss.n145 avss.n65 585
R471 avss.n105 avss.n64 585
R472 avss.n209 avss.n64 585
R473 avss.n140 avss.n139 585
R474 avss.n139 avss.n63 585
R475 avss.n293 avss.n292 585
R476 avss.n292 avss.n291 585
R477 avss.n294 avss.n4 585
R478 avss.n7 avss.n4 585
R479 avss.n295 avss.n3 585
R480 avss.n182 avss.n3 585
R481 avss.n85 avss.n2 585
R482 avss.n183 avss.n85 585
R483 avss.n186 avss.n185 585
R484 avss.n185 avss.n184 585
R485 avss.n189 avss.n84 585
R486 avss.n86 avss.n84 585
R487 avss.n190 avss.n83 585
R488 avss.n172 avss.n83 585
R489 avss.n191 avss.n82 585
R490 avss.n171 avss.n82 585
R491 avss.n169 avss.n80 585
R492 avss.n170 avss.n169 585
R493 avss.n195 avss.n79 585
R494 avss.n93 avss.n79 585
R495 avss.n196 avss.n78 585
R496 avss.n159 avss.n78 585
R497 avss.n197 avss.n77 585
R498 avss.n158 avss.n77 585
R499 avss.n156 avss.n75 585
R500 avss.n157 avss.n156 585
R501 avss.n201 avss.n74 585
R502 avss.n100 avss.n74 585
R503 avss.n202 avss.n73 585
R504 avss.n148 avss.n73 585
R505 avss.n203 avss.n72 585
R506 avss.n147 avss.n72 585
R507 avss.n69 avss.n67 585
R508 avss.n67 avss.n65 585
R509 avss.n208 avss.n207 585
R510 avss.n209 avss.n208 585
R511 avss.n68 avss.n66 585
R512 avss.n66 avss.n63 585
R513 avss.n266 avss.n6 585
R514 avss.n8 avss.n6 585
R515 avss.n268 avss.n267 585
R516 avss.n270 avss.n19 585
R517 avss.n272 avss.n271 585
R518 avss.n273 avss.n18 585
R519 avss.n275 avss.n274 585
R520 avss.n277 avss.n16 585
R521 avss.n279 avss.n278 585
R522 avss.n280 avss.n15 585
R523 avss.n282 avss.n281 585
R524 avss.n284 avss.n13 585
R525 avss.n286 avss.n285 585
R526 avss.n287 avss.n10 585
R527 avss.n138 avss.n106 585
R528 avss.n114 avss.n107 585
R529 avss.n116 avss.n115 585
R530 avss.n118 avss.n117 585
R531 avss.n120 avss.n119 585
R532 avss.n122 avss.n121 585
R533 avss.n124 avss.n123 585
R534 avss.n126 avss.n125 585
R535 avss.n128 avss.n127 585
R536 avss.n130 avss.n129 585
R537 avss.n132 avss.n131 585
R538 avss.n133 avss.n113 585
R539 avss.n135 avss.n134 585
R540 avss.n136 avss.n135 585
R541 avss.n260 avss.n26 431.818
R542 avss.n251 avss.n250 431.818
R543 avss.n136 avss.n63 418.183
R544 avss.n291 avss.n8 418.183
R545 avss.n56 avss.n26 256.663
R546 avss.n54 avss.n26 256.663
R547 avss.n48 avss.n26 256.663
R548 avss.n46 avss.n26 256.663
R549 avss.n40 avss.n26 256.663
R550 avss.n38 avss.n26 256.663
R551 avss.n250 avss.n214 256.663
R552 avss.n250 avss.n215 256.663
R553 avss.n250 avss.n216 256.663
R554 avss.n250 avss.n217 256.663
R555 avss.n250 avss.n218 256.663
R556 avss.n250 avss.n219 256.663
R557 avss.n269 avss.n8 256.663
R558 avss.n20 avss.n8 256.663
R559 avss.n276 avss.n8 256.663
R560 avss.n17 avss.n8 256.663
R561 avss.n283 avss.n8 256.663
R562 avss.n14 avss.n8 256.663
R563 avss.n137 avss.n136 256.663
R564 avss.n136 avss.n108 256.663
R565 avss.n136 avss.n109 256.663
R566 avss.n136 avss.n110 256.663
R567 avss.n136 avss.n111 256.663
R568 avss.n136 avss.n112 256.663
R569 avss.n259 avss.n29 240.244
R570 avss.n253 avss.n29 240.244
R571 avss.n253 avss.n62 240.244
R572 avss.n261 avss.n25 240.244
R573 avss.n212 avss.n25 240.244
R574 avss.n213 avss.n212 240.244
R575 avss.n139 avss.n64 240.244
R576 avss.n145 avss.n64 240.244
R577 avss.n146 avss.n145 240.244
R578 avss.n149 avss.n146 240.244
R579 avss.n149 avss.n101 240.244
R580 avss.n155 avss.n101 240.244
R581 avss.n155 avss.n99 240.244
R582 avss.n160 avss.n99 240.244
R583 avss.n160 avss.n94 240.244
R584 avss.n168 avss.n94 240.244
R585 avss.n168 avss.n92 240.244
R586 avss.n173 avss.n92 240.244
R587 avss.n174 avss.n173 240.244
R588 avss.n174 avss.n87 240.244
R589 avss.n88 avss.n87 240.244
R590 avss.n181 avss.n88 240.244
R591 avss.n181 avss.n9 240.244
R592 avss.n290 avss.n9 240.244
R593 avss.n208 avss.n66 240.244
R594 avss.n208 avss.n67 240.244
R595 avss.n72 avss.n67 240.244
R596 avss.n73 avss.n72 240.244
R597 avss.n74 avss.n73 240.244
R598 avss.n156 avss.n74 240.244
R599 avss.n156 avss.n77 240.244
R600 avss.n78 avss.n77 240.244
R601 avss.n79 avss.n78 240.244
R602 avss.n169 avss.n79 240.244
R603 avss.n169 avss.n82 240.244
R604 avss.n83 avss.n82 240.244
R605 avss.n84 avss.n83 240.244
R606 avss.n185 avss.n84 240.244
R607 avss.n185 avss.n85 240.244
R608 avss.n85 avss.n3 240.244
R609 avss.n4 avss.n3 240.244
R610 avss.n292 avss.n4 240.244
R611 avss.n209 avss.n65 227.274
R612 avss.n147 avss.n65 227.274
R613 avss.n148 avss.n147 227.274
R614 avss.n148 avss.n100 227.274
R615 avss.n157 avss.n100 227.274
R616 avss.n158 avss.n157 227.274
R617 avss.n159 avss.n158 227.274
R618 avss.n159 avss.n93 227.274
R619 avss.n170 avss.n93 227.274
R620 avss.n171 avss.n170 227.274
R621 avss.n172 avss.n171 227.274
R622 avss.n172 avss.n86 227.274
R623 avss.n184 avss.n86 227.274
R624 avss.n184 avss.n183 227.274
R625 avss.n183 avss.n182 227.274
R626 avss.n182 avss.n7 227.274
R627 avss.n291 avss.n7 227.274
R628 avss.n260 avss.n27 227.274
R629 avss.n252 avss.n251 227.274
R630 avss.n210 avss.n63 206.819
R631 avss.n249 avss.n220 163.367
R632 avss.n245 avss.n244 163.367
R633 avss.n241 avss.n240 163.367
R634 avss.n237 avss.n236 163.367
R635 avss.n233 avss.n232 163.367
R636 avss.n229 avss.n228 163.367
R637 avss.n57 avss.n55 163.367
R638 avss.n53 avss.n32 163.367
R639 avss.n49 avss.n47 163.367
R640 avss.n45 avss.n34 163.367
R641 avss.n41 avss.n39 163.367
R642 avss.n37 avss.n24 163.367
R643 avss.n115 avss.n107 163.367
R644 avss.n119 avss.n118 163.367
R645 avss.n123 avss.n122 163.367
R646 avss.n127 avss.n126 163.367
R647 avss.n131 avss.n130 163.367
R648 avss.n135 avss.n113 163.367
R649 avss.n285 avss.n284 163.367
R650 avss.n282 avss.n15 163.367
R651 avss.n278 avss.n277 163.367
R652 avss.n275 avss.n18 163.367
R653 avss.n271 avss.n270 163.367
R654 avss.n268 avss.n6 163.367
R655 avss.n252 avss.n211 140.91
R656 avss.n211 avss.n27 86.3641
R657 avss.n245 avss.n219 71.676
R658 avss.n241 avss.n218 71.676
R659 avss.n237 avss.n217 71.676
R660 avss.n233 avss.n216 71.676
R661 avss.n229 avss.n215 71.676
R662 avss.n225 avss.n214 71.676
R663 avss.n56 avss.n28 71.676
R664 avss.n55 avss.n54 71.676
R665 avss.n48 avss.n32 71.676
R666 avss.n47 avss.n46 71.676
R667 avss.n40 avss.n34 71.676
R668 avss.n39 avss.n38 71.676
R669 avss.n57 avss.n56 71.676
R670 avss.n54 avss.n53 71.676
R671 avss.n49 avss.n48 71.676
R672 avss.n46 avss.n45 71.676
R673 avss.n41 avss.n40 71.676
R674 avss.n38 avss.n37 71.676
R675 avss.n228 avss.n214 71.676
R676 avss.n232 avss.n215 71.676
R677 avss.n236 avss.n216 71.676
R678 avss.n240 avss.n217 71.676
R679 avss.n244 avss.n218 71.676
R680 avss.n220 avss.n219 71.676
R681 avss.n138 avss.n137 71.676
R682 avss.n115 avss.n108 71.676
R683 avss.n119 avss.n109 71.676
R684 avss.n123 avss.n110 71.676
R685 avss.n127 avss.n111 71.676
R686 avss.n131 avss.n112 71.676
R687 avss.n285 avss.n14 71.676
R688 avss.n283 avss.n282 71.676
R689 avss.n278 avss.n17 71.676
R690 avss.n276 avss.n275 71.676
R691 avss.n271 avss.n20 71.676
R692 avss.n269 avss.n268 71.676
R693 avss.n270 avss.n269 71.676
R694 avss.n20 avss.n18 71.676
R695 avss.n277 avss.n276 71.676
R696 avss.n17 avss.n15 71.676
R697 avss.n284 avss.n283 71.676
R698 avss.n14 avss.n10 71.676
R699 avss.n137 avss.n107 71.676
R700 avss.n118 avss.n108 71.676
R701 avss.n122 avss.n109 71.676
R702 avss.n126 avss.n110 71.676
R703 avss.n130 avss.n111 71.676
R704 avss.n113 avss.n112 71.676
R705 avss.n248 avss.n60 31.4438
R706 avss.n257 avss.n59 31.4438
R707 avss.n288 avss.n287 31.4346
R708 avss.n141 avss.n106 31.4346
R709 avss.n226 avss.n224 31.2549
R710 avss.n134 avss.n70 31.2534
R711 avss.n264 avss.n21 31.2167
R712 avss.n266 avss.n265 31.2167
R713 avss.n210 avss.n209 20.455
R714 avss.n207 avss.n68 19.3944
R715 avss.n207 avss.n69 19.3944
R716 avss.n203 avss.n69 19.3944
R717 avss.n203 avss.n202 19.3944
R718 avss.n202 avss.n201 19.3944
R719 avss.n201 avss.n75 19.3944
R720 avss.n197 avss.n75 19.3944
R721 avss.n197 avss.n196 19.3944
R722 avss.n196 avss.n195 19.3944
R723 avss.n195 avss.n80 19.3944
R724 avss.n191 avss.n80 19.3944
R725 avss.n191 avss.n190 19.3944
R726 avss.n190 avss.n189 19.3944
R727 avss.n189 avss.n186 19.3944
R728 avss.n186 avss.n2 19.3944
R729 avss.n295 avss.n2 19.3944
R730 avss.n295 avss.n294 19.3944
R731 avss.n294 avss.n293 19.3944
R732 avss.n258 avss.n30 19.3944
R733 avss.n254 avss.n30 19.3944
R734 avss.n254 avss.n61 19.3944
R735 avss.n262 avss.n23 19.3944
R736 avss.n222 avss.n23 19.3944
R737 avss.n223 avss.n222 19.3944
R738 avss.n140 avss.n105 19.3944
R739 avss.n144 avss.n105 19.3944
R740 avss.n144 avss.n104 19.3944
R741 avss.n150 avss.n104 19.3944
R742 avss.n150 avss.n102 19.3944
R743 avss.n154 avss.n102 19.3944
R744 avss.n154 avss.n98 19.3944
R745 avss.n161 avss.n98 19.3944
R746 avss.n161 avss.n95 19.3944
R747 avss.n167 avss.n95 19.3944
R748 avss.n167 avss.n96 19.3944
R749 avss.n96 avss.n91 19.3944
R750 avss.n175 avss.n91 19.3944
R751 avss.n176 avss.n175 19.3944
R752 avss.n176 avss.n89 19.3944
R753 avss.n180 avss.n89 19.3944
R754 avss.n180 avss.n11 19.3944
R755 avss.n289 avss.n11 19.3944
R756 avss avss.n297 11.3205
R757 avss.n58 avss.n31 10.6151
R758 avss.n116 avss.n114 10.6151
R759 avss.n248 avss.n247 10.6151
R760 avss.n247 avss.n246 10.6151
R761 avss.n246 avss.n243 10.6151
R762 avss.n243 avss.n242 10.6151
R763 avss.n242 avss.n239 10.6151
R764 avss.n239 avss.n238 10.6151
R765 avss.n238 avss.n235 10.6151
R766 avss.n235 avss.n234 10.6151
R767 avss.n234 avss.n231 10.6151
R768 avss.n231 avss.n230 10.6151
R769 avss.n230 avss.n227 10.6151
R770 avss.n227 avss.n226 10.6151
R771 avss.n59 avss.n58 10.6151
R772 avss.n52 avss.n31 10.6151
R773 avss.n52 avss.n51 10.6151
R774 avss.n51 avss.n50 10.6151
R775 avss.n50 avss.n33 10.6151
R776 avss.n44 avss.n33 10.6151
R777 avss.n44 avss.n43 10.6151
R778 avss.n43 avss.n42 10.6151
R779 avss.n42 avss.n35 10.6151
R780 avss.n36 avss.n35 10.6151
R781 avss.n36 avss.n21 10.6151
R782 avss.n287 avss.n286 10.6151
R783 avss.n286 avss.n13 10.6151
R784 avss.n281 avss.n13 10.6151
R785 avss.n281 avss.n280 10.6151
R786 avss.n280 avss.n279 10.6151
R787 avss.n279 avss.n16 10.6151
R788 avss.n274 avss.n16 10.6151
R789 avss.n274 avss.n273 10.6151
R790 avss.n273 avss.n272 10.6151
R791 avss.n272 avss.n19 10.6151
R792 avss.n267 avss.n19 10.6151
R793 avss.n267 avss.n266 10.6151
R794 avss.n114 avss.n106 10.6151
R795 avss.n117 avss.n116 10.6151
R796 avss.n120 avss.n117 10.6151
R797 avss.n121 avss.n120 10.6151
R798 avss.n124 avss.n121 10.6151
R799 avss.n125 avss.n124 10.6151
R800 avss.n128 avss.n125 10.6151
R801 avss.n129 avss.n128 10.6151
R802 avss.n132 avss.n129 10.6151
R803 avss.n133 avss.n132 10.6151
R804 avss.n134 avss.n133 10.6151
R805 avss.n23 avss.n22 9.3005
R806 avss.n222 avss.n221 9.3005
R807 avss.n224 avss.n223 9.3005
R808 avss.n263 avss.n262 9.3005
R809 avss.n258 avss.n257 9.3005
R810 avss.n256 avss.n30 9.3005
R811 avss.n255 avss.n254 9.3005
R812 avss.n61 avss.n60 9.3005
R813 avss.n142 avss.n105 9.3005
R814 avss.n144 avss.n143 9.3005
R815 avss.n104 avss.n103 9.3005
R816 avss.n151 avss.n150 9.3005
R817 avss.n152 avss.n102 9.3005
R818 avss.n154 avss.n153 9.3005
R819 avss.n98 avss.n97 9.3005
R820 avss.n162 avss.n161 9.3005
R821 avss.n163 avss.n95 9.3005
R822 avss.n167 avss.n166 9.3005
R823 avss.n165 avss.n96 9.3005
R824 avss.n164 avss.n91 9.3005
R825 avss.n175 avss.n90 9.3005
R826 avss.n177 avss.n176 9.3005
R827 avss.n178 avss.n89 9.3005
R828 avss.n180 avss.n179 9.3005
R829 avss.n12 avss.n11 9.3005
R830 avss.n289 avss.n288 9.3005
R831 avss.n141 avss.n140 9.3005
R832 avss.n207 avss.n206 9.3005
R833 avss.n205 avss.n69 9.3005
R834 avss.n204 avss.n203 9.3005
R835 avss.n202 avss.n71 9.3005
R836 avss.n201 avss.n200 9.3005
R837 avss.n199 avss.n75 9.3005
R838 avss.n198 avss.n197 9.3005
R839 avss.n196 avss.n76 9.3005
R840 avss.n195 avss.n194 9.3005
R841 avss.n193 avss.n80 9.3005
R842 avss.n192 avss.n191 9.3005
R843 avss.n190 avss.n81 9.3005
R844 avss.n189 avss.n188 9.3005
R845 avss.n187 avss.n186 9.3005
R846 avss.n2 avss.n0 9.3005
R847 avss.n296 avss.n295 9.3005
R848 avss.n294 avss.n1 9.3005
R849 avss.n293 avss.n5 9.3005
R850 avss.n70 avss.n68 9.3005
R851 avss.n265 avss.n264 1.11678
R852 avss.n257 avss.n256 0.152939
R853 avss.n256 avss.n255 0.152939
R854 avss.n255 avss.n60 0.152939
R855 avss.n142 avss.n141 0.152939
R856 avss.n143 avss.n142 0.152939
R857 avss.n143 avss.n103 0.152939
R858 avss.n151 avss.n103 0.152939
R859 avss.n152 avss.n151 0.152939
R860 avss.n153 avss.n152 0.152939
R861 avss.n153 avss.n97 0.152939
R862 avss.n162 avss.n97 0.152939
R863 avss.n163 avss.n162 0.152939
R864 avss.n166 avss.n163 0.152939
R865 avss.n166 avss.n165 0.152939
R866 avss.n165 avss.n164 0.152939
R867 avss.n164 avss.n90 0.152939
R868 avss.n177 avss.n90 0.152939
R869 avss.n178 avss.n177 0.152939
R870 avss.n179 avss.n178 0.152939
R871 avss.n179 avss.n12 0.152939
R872 avss.n288 avss.n12 0.152939
R873 avss.n264 avss.n263 0.0387444
R874 avss.n265 avss.n5 0.0372043
R875 avss.n263 avss.n22 0.0261674
R876 avss.n221 avss.n22 0.0261674
R877 avss.n224 avss.n221 0.0261674
R878 avss.n206 avss.n70 0.0261674
R879 avss.n206 avss.n205 0.0261674
R880 avss.n205 avss.n204 0.0261674
R881 avss.n204 avss.n71 0.0261674
R882 avss.n200 avss.n71 0.0261674
R883 avss.n200 avss.n199 0.0261674
R884 avss.n199 avss.n198 0.0261674
R885 avss.n198 avss.n76 0.0261674
R886 avss.n194 avss.n76 0.0261674
R887 avss.n194 avss.n193 0.0261674
R888 avss.n193 avss.n192 0.0261674
R889 avss.n192 avss.n81 0.0261674
R890 avss.n188 avss.n81 0.0261674
R891 avss.n188 avss.n187 0.0261674
R892 avss.n187 avss.n0 0.0261674
R893 avss.n296 avss.n1 0.0261674
R894 avss.n5 avss.n1 0.0261674
R895 avss.n297 avss.n0 0.0218039
R896 avss.n297 avss.n296 0.00486345
C0 B avdd 1.06876f
C1 A B 0.17392f
C2 A avdd 0.70631f
C3 avss.n0 avss 0.00425f
C4 avss.n1 avss 0.00464f
C5 avss.n2 avss 0
C6 avss.n3 avss 0
C7 avss.n4 avss 0
C8 avss.n5 avss 0.00564f
C9 avss.n6 avss 0.00158f
C10 avss.n7 avss 0.01845f
C11 avss.n8 avss 0.08028f
C12 avss.n9 avss 0
C13 avss.n10 avss 0.00158f
C14 avss.n11 avss 0
C15 avss.n12 avss 0
C16 avss.n13 avss 0
C17 avss.n15 avss 0
C18 avss.n16 avss 0
C19 avss.n18 avss 0
C20 avss.n19 avss 0
C21 avss.n21 avss 0.00107f
C22 avss.n22 avss 0.00464f
C23 avss.n23 avss 0
C24 avss.n24 avss 0.00161f
C25 avss.n25 avss 0
C26 avss.n26 avss 0.08083f
C27 avss.n27 avss 0.01273f
C28 avss.n28 avss 0.00161f
C29 avss.n29 avss 0
C30 avss.n30 avss 0
C31 avss.n31 avss 0.01613f
C32 avss.n32 avss 0
C33 avss.n33 avss 0
C34 avss.n34 avss 0
C35 avss.n35 avss 0
C36 avss.n36 avss 0
C37 avss.n37 avss 0
C38 avss.n39 avss 0
C39 avss.n41 avss 0
C40 avss.n42 avss 0
C41 avss.n43 avss 0
C42 avss.n44 avss 0
C43 avss.n45 avss 0
C44 avss.n47 avss 0
C45 avss.n49 avss 0
C46 avss.n50 avss 0
C47 avss.n51 avss 0
C48 avss.n52 avss 0
C49 avss.n53 avss 0
C50 avss.n55 avss 0
C51 avss.n57 avss 0
C52 avss.n58 avss 0.00458f
C53 avss.n59 avss 0.00109f
C54 avss.n60 avss 0.00279f
C55 avss.n61 avss 0
C56 avss.n62 avss 0.00163f
C57 avss.n63 avss 0.02538f
C58 avss.n64 avss 0
C59 avss.n65 avss 0.01845f
C60 avss.n66 avss 0.00161f
C61 avss.n67 avss 0
C62 avss.n68 avss 0
C63 avss.n69 avss 0
C64 avss.n70 avss 0.0102f
C65 avss.n71 avss 0.00464f
C66 avss.n72 avss 0
C67 avss.n73 avss 0
C68 avss.n74 avss 0
C69 avss.n75 avss 0
C70 avss.n76 avss 0.00464f
C71 avss.n77 avss 0
C72 avss.n78 avss 0
C73 avss.n79 avss 0
C74 avss.n80 avss 0
C75 avss.n81 avss 0.00464f
C76 avss.n82 avss 0
C77 avss.n83 avss 0
C78 avss.n84 avss 0
C79 avss.n85 avss 0
C80 avss.n86 avss 0.01845f
C81 avss.n87 avss 0
C82 avss.n88 avss 0
C83 avss.n89 avss 0
C84 avss.n90 avss 0
C85 avss.n91 avss 0
C86 avss.n92 avss 0
C87 avss.n93 avss 0.01845f
C88 avss.n94 avss 0
C89 avss.n95 avss 0
C90 avss.n96 avss 0
C91 avss.n97 avss 0
C92 avss.n98 avss 0
C93 avss.n99 avss 0
C94 avss.n100 avss 0.01845f
C95 avss.n101 avss 0
C96 avss.n102 avss 0
C97 avss.n103 avss 0
C98 avss.n104 avss 0
C99 avss.n105 avss 0
C100 avss.n106 avss 0.00109f
C101 avss.n107 avss 0
C102 avss.n113 avss 0
C103 avss.n114 avss 0.00627f
C104 avss.n115 avss 0
C105 avss.n116 avss 0.02266f
C106 avss.n117 avss 0
C107 avss.n118 avss 0
C108 avss.n119 avss 0
C109 avss.n120 avss 0
C110 avss.n121 avss 0
C111 avss.n122 avss 0
C112 avss.n123 avss 0
C113 avss.n124 avss 0
C114 avss.n125 avss 0
C115 avss.n126 avss 0
C116 avss.n127 avss 0
C117 avss.n128 avss 0
C118 avss.n129 avss 0
C119 avss.n130 avss 0
C120 avss.n131 avss 0
C121 avss.n132 avss 0
C122 avss.n133 avss 0
C123 avss.n134 avss 0.00108f
C124 avss.n135 avss 0.00158f
C125 avss.n136 avss 0.10981f
C126 avss.n138 avss 0.00158f
C127 avss.n139 avss 0.00161f
C128 avss.n140 avss 0
C129 avss.n141 avss 0.00274f
C130 avss.n142 avss 0
C131 avss.n143 avss 0
C132 avss.n144 avss 0
C133 avss.n145 avss 0
C134 avss.n146 avss 0
C135 avss.n147 avss 0.01845f
C136 avss.n148 avss 0.01845f
C137 avss.n149 avss 0
C138 avss.n150 avss 0
C139 avss.n151 avss 0
C140 avss.n152 avss 0
C141 avss.n153 avss 0
C142 avss.n154 avss 0
C143 avss.n155 avss 0
C144 avss.n156 avss 0
C145 avss.n157 avss 0.01845f
C146 avss.n158 avss 0.01845f
C147 avss.n159 avss 0.01845f
C148 avss.n160 avss 0
C149 avss.n161 avss 0
C150 avss.n162 avss 0
C151 avss.n163 avss 0
C152 avss.n164 avss 0
C153 avss.n165 avss 0
C154 avss.n166 avss 0
C155 avss.n167 avss 0
C156 avss.n168 avss 0
C157 avss.n169 avss 0
C158 avss.n170 avss 0.01845f
C159 avss.n171 avss 0.01845f
C160 avss.n172 avss 0.01845f
C161 avss.n173 avss 0
C162 avss.n174 avss 0
C163 avss.n175 avss 0
C164 avss.n176 avss 0
C165 avss.n177 avss 0
C166 avss.n178 avss 0
C167 avss.n179 avss 0
C168 avss.n180 avss 0
C169 avss.n181 avss 0
C170 avss.n182 avss 0.01845f
C171 avss.n183 avss 0.01845f
C172 avss.n184 avss 0.01845f
C173 avss.n185 avss 0
C174 avss.n186 avss 0
C175 avss.n187 avss 0.00464f
C176 avss.n188 avss 0.00464f
C177 avss.n189 avss 0
C178 avss.n190 avss 0
C179 avss.n191 avss 0
C180 avss.n192 avss 0.00464f
C181 avss.n193 avss 0.00464f
C182 avss.n194 avss 0.00464f
C183 avss.n195 avss 0
C184 avss.n196 avss 0
C185 avss.n197 avss 0
C186 avss.n198 avss 0.00464f
C187 avss.n199 avss 0.00464f
C188 avss.n200 avss 0.00464f
C189 avss.n201 avss 0
C190 avss.n202 avss 0
C191 avss.n203 avss 0
C192 avss.n204 avss 0.00464f
C193 avss.n205 avss 0.00464f
C194 avss.n206 avss 0.00464f
C195 avss.n207 avss 0
C196 avss.n208 avss 0
C197 avss.n209 avss 0.01006f
C198 avss.n210 avss 0.41823f
C199 avss.n211 avss 0.10234f
C200 avss.n212 avss 0
C201 avss.n213 avss 0.00163f
C202 avss.n220 avss 0
C203 avss.n221 avss 0.00464f
C204 avss.n222 avss 0
C205 avss.n223 avss 0
C206 avss.n224 avss 0.01048f
C207 avss.n225 avss 0.00161f
C208 avss.n226 avss 0.00108f
C209 avss.n227 avss 0
C210 avss.n228 avss 0
C211 avss.n229 avss 0
C212 avss.n230 avss 0
C213 avss.n231 avss 0
C214 avss.n232 avss 0
C215 avss.n233 avss 0
C216 avss.n234 avss 0
C217 avss.n235 avss 0
C218 avss.n236 avss 0
C219 avss.n237 avss 0
C220 avss.n238 avss 0
C221 avss.n239 avss 0
C222 avss.n240 avss 0
C223 avss.n241 avss 0
C224 avss.n242 avss 0
C225 avss.n243 avss 0
C226 avss.n244 avss 0
C227 avss.n245 avss 0
C228 avss.n246 avss 0
C229 avss.n247 avss 0
C230 avss.n248 avss 0.00109f
C231 avss.n249 avss 0.00161f
C232 avss.n250 avss 0.11036f
C233 avss.n251 avss 0.02676f
C234 avss.n252 avss 0.01495f
C235 avss.n253 avss 0
C236 avss.n254 avss 0
C237 avss.n255 avss 0
C238 avss.n256 avss 0
C239 avss.n257 avss 0.00279f
C240 avss.n258 avss 0
C241 avss.n259 avss 0.00163f
C242 avss.n260 avss 0.02676f
C243 avss.n261 avss 0.00163f
C244 avss.n262 avss 0
C245 avss.n263 avss 0.00578f
C246 avss.n264 avss 0.00785f
C247 avss.n265 avss 0.00771f
C248 avss.n266 avss 0.00107f
C249 avss.n267 avss 0
C250 avss.n268 avss 0
C251 avss.n270 avss 0
C252 avss.n271 avss 0
C253 avss.n272 avss 0
C254 avss.n273 avss 0
C255 avss.n274 avss 0
C256 avss.n275 avss 0
C257 avss.n277 avss 0
C258 avss.n278 avss 0
C259 avss.n279 avss 0
C260 avss.n280 avss 0
C261 avss.n281 avss 0
C262 avss.n282 avss 0
C263 avss.n284 avss 0
C264 avss.n285 avss 0
C265 avss.n286 avss 0
C266 avss.n287 avss 0.00109f
C267 avss.n288 avss 0.00274f
C268 avss.n289 avss 0
C269 avss.n290 avss 0.00161f
C270 avss.n291 avss 0.02621f
C271 avss.n292 avss 0.00161f
C272 avss.n293 avss 0
C273 avss.n294 avss 0
C274 avss.n295 avss 0
C275 avss.n296 avss 0.00272f
C276 avss.n297 avss 0.00568f
C277 avdd.n0 avss 0.01006f
C278 avdd.n1 avss 0.01571f
C279 avdd.n2 avss 0.00209f
C280 avdd.n3 avss 0.00259f
C281 avdd.n4 avss 0.00259f
C282 avdd.n5 avss 0.00481f
C283 avdd.n6 avss 0.00359f
C284 avdd.n7 avss 0.01698f
C285 avdd.n8 avss 0.00209f
C286 avdd.n9 avss 0.00513f
C287 avdd.n10 avss 0.00259f
C288 avdd.n12 avss 0.01668f
C289 avdd.n13 avss 0.00526f
C290 avdd.n14 avss 0.00176f
C291 avdd.n15 avss 0.00173f
C292 avdd.n16 avss 0.03539f
C293 avdd.n17 avss 0.00176f
C294 avdd.n18 avss 0.00176f
C295 avdd.n19 avss 0.00176f
C296 avdd.n20 avss 0.00176f
C297 avdd.n21 avss 0.00176f
C298 avdd.n22 avss 0.01668f
C299 avdd.n23 avss 0.00176f
C300 avdd.n24 avss 0.00176f
C301 avdd.n25 avss 0.00176f
C302 avdd.n26 avss 0.00176f
C303 avdd.n27 avss 0.00176f
C304 avdd.n28 avss 0.00176f
C305 avdd.n29 avss 0.01668f
C306 avdd.n30 avss 0.00176f
C307 avdd.n31 avss 0.0089f
C308 avdd.n32 avss 0.00526f
C309 avdd.n33 avss 0.00513f
C310 avdd.n35 avss 0.00259f
C311 avdd.n36 avss 0.00173f
C312 avdd.n37 avss 0.00209f
C313 avdd.n38 avss 0.00176f
C314 avdd.n39 avss 0.02056f
C315 avdd.n40 avss 0.0134f
C316 avdd.n41 avss 0.00176f
C317 avdd.n42 avss 0.00176f
C318 avdd.n43 avss 0.00176f
C319 avdd.n44 avss 0.00176f
C320 avdd.n45 avss 0.00176f
C321 avdd.n46 avss 0.00176f
C322 avdd.n47 avss 0.00176f
C323 avdd.n48 avss 0.00176f
C324 avdd.n49 avss 0.00176f
C325 avdd.n50 avss 0.00363f
C326 avdd.n51 avss 0.00259f
C327 avdd.n52 avss 0.0089f
C328 avdd.n53 avss 0.00173f
C329 avdd.n54 avss 0.00526f
C330 avdd.n55 avss 0.04515f
C331 avdd.n56 avss 0.02576f
C332 avdd.n57 avss 0.00513f
C333 avdd.n58 avss 0.00363f
C334 avdd.n59 avss 0.00176f
C335 avdd.n60 avss 0.00176f
C336 avdd.n61 avss 0.00176f
C337 avdd.n62 avss 0.01668f
C338 avdd.n63 avss 0.01668f
C339 avdd.n64 avss 0.01668f
C340 avdd.n65 avss 0.00176f
C341 avdd.n66 avss 0.00176f
C342 avdd.n67 avss 0.00176f
C343 avdd.n68 avss 0.00176f
C344 avdd.n69 avss 0.00176f
C345 avdd.n70 avss 0.01668f
C346 avdd.n71 avss 0.01668f
C347 avdd.n72 avss 0.01668f
C348 avdd.n73 avss 0.00176f
C349 avdd.n74 avss 0.00176f
C350 avdd.n75 avss 0.00176f
C351 avdd.n76 avss 0.0036f
C352 avdd.n77 avss 0.00513f
C353 avdd.n78 avss 0.02576f
C354 avdd.n79 avss 0.04515f
C355 avdd.n80 avss 0.00526f
C356 avdd.n81 avss 0.00173f
C357 avdd.n82 avss 0.01987f
C358 avdd.n83 avss 0.02625f
C359 avdd.n84 avss 0.00176f
C360 avdd.n85 avss 0.08031f
C361 avdd.n86 avss 0.00176f
C362 avdd.n87 avss 0.00176f
C363 avdd.n88 avss 0.00176f
C364 avdd.n90 avss 0.00176f
C365 avdd.n91 avss 0.00176f
C366 avdd.n93 avss 0.00483f
C367 avdd.n94 avss 0.00259f
C368 avdd.n95 avss 0.00209f
C369 avdd.n96 avss 0.00259f
C370 avdd.n97 avss 0.04016f
C371 avdd.n98 avss 0.00259f
C372 avdd.n99 avss 0.00209f
C373 avdd.n100 avss 0.00259f
C374 avdd.n101 avss 0.00209f
C375 avdd.n102 avss 0.00259f
C376 avdd.n103 avss 0.04016f
C377 avdd.n104 avss 0.00259f
C378 avdd.n105 avss 0.00259f
C379 avdd.n106 avss 0.00209f
C380 avdd.n107 avss 0.03253f
C381 avdd.n108 avss 0.00173f
C382 avdd.n109 avss 0.00481f
C383 avdd.n110 avss 0.05501f
C384 avdd.n111 avss 0.00481f
C385 avdd.n112 avss 0.00173f
C386 avdd.n113 avss 0.00176f
C387 avdd.n114 avss 0.00176f
C388 avdd.n120 avss 0.00176f
C389 avdd.n121 avss 0.00483f
C390 avdd.n122 avss 0.00326f
C391 avdd.n123 avss 0.02205f
C392 avdd.n124 avss 0.00176f
C393 avdd.n125 avss 0.00176f
C394 avdd.n126 avss 0.08003f
C395 avdd.n127 avss 0.00176f
C396 avdd.n128 avss 0.00176f
C397 avdd.n129 avss 0.00176f
C398 avdd.n130 avss 0.00176f
C399 avdd.n131 avss 0.00176f
C400 avdd.n132 avss 0.00176f
C401 avdd.n133 avss 0.00176f
C402 avdd.n134 avss 0.00176f
C403 avdd.n135 avss 0.00176f
C404 avdd.n136 avss 0.00176f
C405 avdd.n137 avss 0.00176f
C406 avdd.n138 avss 0.00176f
C407 avdd.n139 avss 0.00176f
C408 avdd.n140 avss 0.00176f
C409 avdd.n141 avss 0.00176f
C410 avdd.n143 avss 0.08031f
C411 avdd.n144 avss 0.00483f
C412 avdd.n145 avss 0.00328f
C413 avdd.n146 avss 0.00849f
C414 avdd.n147 avss 0.00259f
C415 avdd.n148 avss 0.00209f
C416 avdd.n149 avss 0.00259f
C417 avdd.n150 avss 0.04016f
C418 avdd.n151 avss 0.00259f
C419 avdd.n152 avss 0.00209f
C420 avdd.n153 avss 0.01571f
C421 avdd.n154 avss 0.01571f
C422 avdd.n155 avss 0.01571f
C423 avdd.n156 avss 0.00209f
C424 avdd.n157 avss 0.00259f
C425 avdd.n158 avss 0.04016f
C426 avdd.n159 avss 0.00259f
C427 avdd.n160 avss 0.00209f
C428 avdd.n161 avss 0.00259f
C429 avdd.n162 avss 0.00259f
C430 avdd.n163 avss 0.00259f
C431 avdd.n164 avss 0.00209f
C432 avdd.n165 avss 0.00259f
C433 avdd.n166 avss 0.04016f
C434 avdd.n167 avss 0.04016f
C435 avdd.n168 avss 0.05501f
C436 avdd.n169 avss 0.00481f
C437 avdd.n170 avss 0.00173f
C438 avdd.n171 avss 0.00849f
C439 avdd.n172 avss 0.00328f
C440 avdd.n173 avss 0.00176f
C441 avdd.n174 avss 0.00176f
C442 avdd.n176 avss 0.00176f
C443 avdd.n177 avss 0.00176f
C444 avdd.n178 avss 0.00176f
C445 avdd.n179 avss 0.00176f
C446 avdd.n180 avss 0.00176f
C447 avdd.n181 avss 0.00176f
C448 avdd.n183 avss 0.00176f
C449 avdd.n184 avss 0.00176f
C450 avdd.n185 avss 0.00176f
C451 avdd.n186 avss 0.00176f
C452 avdd.n187 avss 0.00176f
C453 avdd.n188 avss 0.00176f
C454 avdd.n190 avss 0.00176f
C455 avdd.n191 avss 0.00176f
C456 avdd.n193 avss 0.00483f
C457 avdd.n194 avss 0.00324f
C458 avdd.n195 avss 0.02495f
C459 avdd.n196 avss 0.01831f
C460 avdd.n197 avss 0.00173f
C461 avdd.n198 avss 0.00209f
C462 avdd.n199 avss 0.00209f
C463 avdd.n200 avss 0.01351f
C464 avdd.n201 avss 0.01899f
C465 A.n0 avss 0.03752f
C466 A.n1 avss 0.04096f
C467 A.n2 avss 0.2135f
C468 A.n3 avss 0.02085f
C469 A.n4 avss 0.02085f
C470 A.n5 avss 0.03107f
C471 A.n6 avss 0.00709f
C472 A.n7 avss 0.00709f
C473 A.n8 avss 0.05019f
C474 A.n9 avss 0.19496f
C475 A.n10 avss 0.07924f
C476 A.n11 avss 0.35675f
C477 A.n12 avss 0.3499f
C478 A.n13 avss 0.44736f
C479 B.n0 avss 0.01112f
C480 B.n1 avss 0.01112f
C481 B.n2 avss 0.04871f
C482 B.n3 avss 0.01112f
C483 B.n4 avss 0.01112f
C484 B.n5 avss 0.04831f
C485 B.n6 avss 0.28417f
C486 B.n7 avss 0.01803f
C487 B.n8 avss 0.05584f
C488 B.n9 avss 0.05584f
C489 B.n10 avss 0.05584f
C490 B.n11 avss 0.04206f
C491 B.n12 avss 0.06015f
C492 B.n13 avss 0.03605f
C493 B.n14 avss 0.0594f
C494 B.n15 avss 0.00409f
C495 B.n16 avss 0.04206f
C496 B.n17 avss 0.04022f
C497 B.n18 avss 0.08204f
C498 B.n19 avss 0.39208f
C499 B avss -0.48265f
C500 A avss -0.95848f
C501 avdd avss -2.55839f
.ends
