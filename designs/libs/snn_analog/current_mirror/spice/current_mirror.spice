* NGSPICE file created from current_mirror.ext - technology: gf180mcuD

.subckt M3 a_n170_n881# a_50_n881# w_n436_n1309# a_n50_n1089# VSUBS
X0 a_50_n881# a_n50_n1089# a_n170_n881# w_n436_n1309# pfet_03v3 ad=4.8p pd=17.2u as=4.8p ps=17.2u w=8u l=0.5u
C0 a_50_n881# a_n50_n1089# 0.1511f
C1 w_n436_n1309# a_n170_n881# 0.85443f
C2 a_50_n881# a_n170_n881# 1.38159f
C3 a_n50_n1089# a_n170_n881# 0.1643f
C4 a_50_n881# w_n436_n1309# 1.11309f
C5 a_n50_n1089# w_n436_n1309# 0.40291f
C6 a_50_n881# VSUBS 0.22915f
C7 a_n170_n881# VSUBS 0.23296f
C8 a_n50_n1089# VSUBS 0.05695f
C9 w_n436_n1309# VSUBS 8.14076f
.ends

.subckt M1 a_n50_n689# a_n388_n853# a_28_n481# a_n178_n481#
X0 a_28_n481# a_n50_n689# a_n178_n481# a_n388_n853# nfet_03v3 ad=3p pd=9.5u as=3p ps=9.5u w=4u l=0.28u
C0 a_n50_n689# a_28_n481# 0.04852f
C1 a_n178_n481# a_28_n481# 0.79223f
C2 a_n178_n481# a_n50_n689# 0.05931f
C3 a_28_n481# a_n388_n853# 0.91438f
C4 a_n178_n481# a_n388_n853# 0.65403f
C5 a_n50_n689# a_n388_n853# 0.43511f
.ends

.subckt M4 a_n170_n241# a_50_n241# w_n436_n669# a_n50_n449# VSUBS
X0 a_50_n241# a_n50_n449# a_n170_n241# w_n436_n669# pfet_03v3 ad=0.96p pd=4.4u as=0.96p ps=4.4u w=1.6u l=0.5u
C0 a_50_n241# a_n50_n449# 0.03432f
C1 w_n436_n669# a_n170_n241# 0.31605f
C2 a_50_n241# a_n170_n241# 0.49483f
C3 a_n50_n449# a_n170_n241# 0.0504f
C4 a_50_n241# w_n436_n669# 0.57366f
C5 a_n50_n449# w_n436_n669# 0.40991f
C6 a_50_n241# VSUBS 0.07004f
C7 a_n170_n241# VSUBS 0.06917f
C8 a_n50_n449# VSUBS 0.05013f
C9 w_n436_n669# VSUBS 4.31562f
.ends

.subckt M2 a_n400_n689# a_n520_n481# a_400_n481# a_n730_n853#
X0 a_400_n481# a_n400_n689# a_n520_n481# a_n730_n853# nfet_03v3 ad=2.4p pd=9.2u as=2.4p ps=9.2u w=4u l=4u
C0 a_n400_n689# a_400_n481# 0.25939f
C1 a_n520_n481# a_400_n481# 0.60052f
C2 a_n520_n481# a_n400_n689# 0.38556f
C3 a_400_n481# a_n730_n853# 1.23378f
C4 a_n520_n481# a_n730_n853# 0.71367f
C5 a_n400_n689# a_n730_n853# 1.90584f
.ends

.subckt current_mirror avss avdd A B
XM3_0 avdd B avdd B avss M3
XM1_0 A avss A avss M1
XM4_0 avdd A avdd A avss M4
XM2_0 A avss B avss M2
R0 B.n2 B.n1 87.6185
R1 B.n2 B.n0 13.0311
R2 B B.n2 9.6305
R3 A.n5 A.n3 88.4721
R4 A.n2 A.n1 40.6645
R5 A A.n7 15.7696
R6 A.n2 A.n0 14.5508
R7 A.n5 A.n4 11.8027
R8 A A.n6 9.9995
R9 A.n6 A.n2 0.9455
R10 A.n6 A.n5 0.4775
R11 avdd.n34 avdd.n23 1397.13
R12 avdd.n34 avdd.n33 1397.13
R13 avdd.n15 avdd.n4 663.191
R14 avdd.n7 avdd.n4 663.191
R15 avdd.n36 avdd.n35 126.439
R16 avdd.n35 avdd.n24 126.439
R17 avdd.n32 avdd.n26 126.439
R18 avdd.n26 avdd.n25 126.439
R19 avdd.n16 avdd.n3 70.438
R20 avdd.n8 avdd.n3 70.438
R21 avdd.n13 avdd.n5 70.438
R22 avdd.n14 avdd.n13 70.438
R23 avdd avdd.n40 13.5293
R24 avdd.n40 avdd.n19 6.88949
R25 avdd.n9 avdd.n8 6.3005
R26 avdd.n10 avdd.n5 6.3005
R27 avdd.n17 avdd.n16 6.3005
R28 avdd.n14 avdd.n2 6.3005
R29 avdd.n27 avdd.n24 6.3005
R30 avdd.n32 avdd.n31 6.3005
R31 avdd.n25 avdd.n22 6.3005
R32 avdd.n37 avdd.n36 6.3005
R33 avdd.n30 avdd.n28 5.92113
R34 avdd.n29 avdd.n20 5.92113
R35 avdd.n28 avdd.n21 5.9133
R36 avdd.n12 avdd.n11 5.29504
R37 avdd.n6 avdd.n0 5.29504
R38 avdd.n12 avdd.n1 5.28722
R39 avdd.n40 avdd.n39 5.0718
R40 avdd.n19 avdd.n18 4.7345
R41 avdd.n39 avdd.n38 4.7345
R42 avdd.n18 avdd.n17 4.5005
R43 avdd.n2 avdd.n1 4.5005
R44 avdd.n9 avdd.n6 4.5005
R45 avdd.n11 avdd.n10 4.5005
R46 avdd.n22 avdd.n21 4.5005
R47 avdd.n38 avdd.n37 4.5005
R48 avdd.n29 avdd.n27 4.5005
R49 avdd.n31 avdd.n30 4.5005
R50 avdd.n7 avdd.n5 3.31679
R51 avdd.n8 avdd.n7 3.31679
R52 avdd.n15 avdd.n14 3.31679
R53 avdd.n16 avdd.n15 3.31679
R54 avdd.n33 avdd.n32 3.31679
R55 avdd.n33 avdd.n24 3.31679
R56 avdd.n36 avdd.n23 3.31679
R57 avdd.n25 avdd.n23 3.31679
R58 avdd.n39 avdd.n20 1.18713
R59 avdd.n13 avdd.n12 0.7005
R60 avdd.n13 avdd.n4 0.7005
R61 avdd.n3 avdd.n0 0.7005
R62 avdd.n4 avdd.n3 0.7005
R63 avdd.n19 avdd.n0 0.561043
R64 avdd.n28 avdd.n26 0.274413
R65 avdd.n34 avdd.n26 0.274413
R66 avdd.n35 avdd.n20 0.274413
R67 avdd.n35 avdd.n34 0.274413
R68 avdd.n10 avdd.n9 0.1445
R69 avdd.n17 avdd.n2 0.1445
R70 avdd.n18 avdd.n1 0.1445
R71 avdd.n11 avdd.n6 0.1445
R72 avdd.n31 avdd.n27 0.1445
R73 avdd.n37 avdd.n22 0.1445
R74 avdd.n38 avdd.n21 0.1445
R75 avdd.n30 avdd.n29 0.1445
R76 avss.n43 avss.n42 21239.1
R77 avss.n33 avss.n7 799.466
R78 avss.n66 avss.n7 364.974
R79 avss.n33 avss.n22 337.663
R80 avss.n43 avss.n19 288.007
R81 avss.n50 avss.n19 198.625
R82 avss.n50 avss.n13 198.625
R83 avss.n58 avss.n13 198.625
R84 avss.n58 avss.n6 198.625
R85 avss.n66 avss.n6 198.625
R86 avss.n42 avss.n41 131.589
R87 avss.n44 avss.n20 104.514
R88 avss.n44 avss.n18 104.514
R89 avss.n65 avss.n5 104.514
R90 avss.n67 avss.n5 104.514
R91 avss.n34 avss.n24 102.376
R92 avss.n40 avss.n25 102.376
R93 avss.n34 avss.n32 102.376
R94 avss.n25 avss.n23 77.6615
R95 avss.n44 avss.n43 77.3391
R96 avss.n42 avss.n22 67.0364
R97 avss.n40 avss.n24 15.5561
R98 avss.n32 avss.n28 15.5561
R99 avss.n49 avss.n20 15.5561
R100 avss.n49 avss.n12 15.5561
R101 avss.n59 avss.n12 15.5561
R102 avss.n59 avss.n8 15.5561
R103 avss.n65 avss.n8 15.5561
R104 avss.n51 avss.n18 15.5561
R105 avss.n51 avss.n14 15.5561
R106 avss.n57 avss.n14 15.5561
R107 avss.n57 avss.n4 15.5561
R108 avss.n67 avss.n4 15.5561
R109 avss avss.n71 13.5221
R110 avss.n71 avss.n0 6.08215
R111 avss.n45 avss.n16 5.55683
R112 avss.n63 avss.n1 5.55683
R113 avss.n46 avss.n45 5.549
R114 avss.n38 avss.n37 5.53703
R115 avss.n35 avss.n27 5.53703
R116 avss.n36 avss.n35 5.5292
R117 avss.n30 avss.n28 5.2005
R118 avss.n32 avss.n31 5.2005
R119 avss.n32 avss.n22 5.2005
R120 avss.n26 avss.n24 5.2005
R121 avss.n24 avss.n22 5.2005
R122 avss.n40 avss.n39 5.2005
R123 avss.n41 avss.n40 5.2005
R124 avss.n65 avss.n64 5.2005
R125 avss.n66 avss.n65 5.2005
R126 avss.n9 avss.n8 5.2005
R127 avss.n8 avss.n6 5.2005
R128 avss.n60 avss.n59 5.2005
R129 avss.n59 avss.n58 5.2005
R130 avss.n12 avss.n11 5.2005
R131 avss.n13 avss.n12 5.2005
R132 avss.n49 avss.n48 5.2005
R133 avss.n50 avss.n49 5.2005
R134 avss.n21 avss.n20 5.2005
R135 avss.n20 avss.n19 5.2005
R136 avss.n68 avss.n67 5.2005
R137 avss.n67 avss.n66 5.2005
R138 avss.n4 avss.n3 5.2005
R139 avss.n6 avss.n4 5.2005
R140 avss.n57 avss.n56 5.2005
R141 avss.n58 avss.n57 5.2005
R142 avss.n15 avss.n14 5.2005
R143 avss.n14 avss.n13 5.2005
R144 avss.n52 avss.n51 5.2005
R145 avss.n51 avss.n50 5.2005
R146 avss.n18 avss.n17 5.2005
R147 avss.n19 avss.n18 5.2005
R148 avss.n71 avss.n70 4.87615
R149 avss.n70 avss.n69 4.7615
R150 avss.n29 avss.n0 4.7417
R151 avss.n36 avss.n26 4.5005
R152 avss.n39 avss.n38 4.5005
R153 avss.n30 avss.n29 4.5005
R154 avss.n31 avss.n27 4.5005
R155 avss.n53 avss.n52 4.5005
R156 avss.n54 avss.n15 4.5005
R157 avss.n56 avss.n55 4.5005
R158 avss.n3 avss.n2 4.5005
R159 avss.n69 avss.n68 4.5005
R160 avss.n17 avss.n16 4.5005
R161 avss.n48 avss.n47 4.5005
R162 avss.n11 avss.n10 4.5005
R163 avss.n61 avss.n60 4.5005
R164 avss.n62 avss.n9 4.5005
R165 avss.n64 avss.n63 4.5005
R166 avss.n46 avss.n21 4.5005
R167 avss.n41 avss.n23 3.94566
R168 avss.n28 avss.n23 1.19566
R169 avss.n37 avss.n0 0.795826
R170 avss.n70 avss.n1 0.795826
R171 avss.n35 avss.n34 0.371929
R172 avss.n34 avss.n33 0.371929
R173 avss.n37 avss.n25 0.371929
R174 avss.n45 avss.n44 0.371929
R175 avss.n5 avss.n1 0.371929
R176 avss.n7 avss.n5 0.371929
R177 avss.n31 avss.n30 0.1445
R178 avss.n39 avss.n26 0.1445
R179 avss.n38 avss.n36 0.1445
R180 avss.n29 avss.n27 0.1445
R181 avss.n48 avss.n21 0.1445
R182 avss.n48 avss.n11 0.1445
R183 avss.n60 avss.n11 0.1445
R184 avss.n60 avss.n9 0.1445
R185 avss.n64 avss.n9 0.1445
R186 avss.n52 avss.n17 0.1445
R187 avss.n52 avss.n15 0.1445
R188 avss.n56 avss.n15 0.1445
R189 avss.n56 avss.n3 0.1445
R190 avss.n68 avss.n3 0.1445
R191 avss.n53 avss.n16 0.1445
R192 avss.n54 avss.n53 0.1445
R193 avss.n55 avss.n54 0.1445
R194 avss.n55 avss.n2 0.1445
R195 avss.n69 avss.n2 0.1445
R196 avss.n47 avss.n46 0.1445
R197 avss.n47 avss.n10 0.1445
R198 avss.n61 avss.n10 0.1445
R199 avss.n62 avss.n61 0.1445
R200 avss.n63 avss.n62 0.1445
C0 avdd A 0.62117f
C1 A B 0.12135f
C2 avdd B 0.7896f
C3 avss.n0 avss 0.00703f
C4 avss.n1 avss 0.00845f
C5 avss.n2 avss 0.0012f
C6 avss.n3 avss 0.0012f
C7 avss.n4 avss 0
C8 avss.n5 avss 0.00591f
C9 avss.n6 avss 0.03139f
C10 avss.n7 avss 0.092f
C11 avss.n8 avss 0
C12 avss.n9 avss 0.0012f
C13 avss.n10 avss 0.0012f
C14 avss.n11 avss 0.0012f
C15 avss.n12 avss 0
C16 avss.n13 avss 0.03139f
C17 avss.n14 avss 0
C18 avss.n15 avss 0.0012f
C19 avss.n16 avss 0.00354f
C20 avss.n17 avss 0
C21 avss.n18 avss 0.00347f
C22 avss.n19 avss 0.03845f
C23 avss.n20 avss 0.00347f
C24 avss.n21 avss 0
C25 avss.n22 avss 0.03198f
C26 avss.n24 avss 0.00342f
C27 avss.n25 avss 0.12884f
C28 avss.n26 avss 0
C29 avss.n27 avss 0.00339f
C30 avss.n28 avss 0.00342f
C31 avss.n29 avss 0.00291f
C32 avss.n30 avss 0
C33 avss.n31 avss 0
C34 avss.n32 avss 0.00342f
C35 avss.n33 avss 0.08984f
C36 avss.n34 avss 0.00578f
C37 avss.n35 avss 0.0178f
C38 avss.n36 avss 0.00398f
C39 avss.n37 avss 0.00844f
C40 avss.n38 avss 0.00339f
C41 avss.n39 avss 0
C42 avss.n40 avss 0.00342f
C43 avss.n41 avss 0.03721f
C44 avss.n42 avss 0.3548f
C45 avss.n43 avss 0.32872f
C46 avss.n44 avss 0.10801f
C47 avss.n45 avss 0.02416f
C48 avss.n46 avss 0.00471f
C49 avss.n47 avss 0.0012f
C50 avss.n48 avss 0.0012f
C51 avss.n49 avss 0
C52 avss.n50 avss 0.03139f
C53 avss.n51 avss 0
C54 avss.n52 avss 0.0012f
C55 avss.n53 avss 0.0012f
C56 avss.n54 avss 0.0012f
C57 avss.n55 avss 0.0012f
C58 avss.n56 avss 0.0012f
C59 avss.n57 avss 0
C60 avss.n58 avss 0.03139f
C61 avss.n59 avss 0
C62 avss.n60 avss 0.0012f
C63 avss.n61 avss 0.0012f
C64 avss.n62 avss 0.0012f
C65 avss.n63 avss 0.00354f
C66 avss.n64 avss 0
C67 avss.n65 avss 0.00347f
C68 avss.n66 avss 0.04453f
C69 avss.n67 avss 0.00347f
C70 avss.n68 avss 0
C71 avss.n69 avss 0.00307f
C72 avss.n70 avss 0.00594f
C73 avss.n71 avss 0.01089f
C74 avdd.n0 avss 0.01422f
C75 avdd.n1 avss 0.0073f
C76 avdd.n2 avss 0.00225f
C77 avdd.n3 avss 0.01031f
C78 avdd.n4 avss 0.08723f
C79 avdd.n5 avss 0.00631f
C80 avdd.n6 avss 0.00719f
C81 avdd.n7 avss 0.05722f
C82 avdd.n8 avss 0.00631f
C83 avdd.n9 avss 0.00225f
C84 avdd.n10 avss 0.00225f
C85 avdd.n11 avss 0.00719f
C86 avdd.n12 avss 0.02183f
C87 avdd.n13 avss 0.01031f
C88 avdd.n14 avss 0.00631f
C89 avdd.n15 avss 0.05722f
C90 avdd.n16 avss 0.00631f
C91 avdd.n17 avss 0.00225f
C92 avdd.n18 avss 0.00659f
C93 avdd.n19 avss 0.02569f
C94 avdd.n20 avss 0.02792f
C95 avdd.n21 avss 0.01329f
C96 avdd.n22 avss 0.00225f
C97 avdd.n23 avss 0.10547f
C98 avdd.n24 avss 0.01035f
C99 avdd.n25 avss 0.01035f
C100 avdd.n26 avss 0.01815f
C101 avdd.n27 avss 0.00225f
C102 avdd.n28 avss 0.06339f
C103 avdd.n29 avss 0.00875f
C104 avdd.n30 avss 0.00875f
C105 avdd.n31 avss 0.00225f
C106 avdd.n32 avss 0.01035f
C107 avdd.n33 avss 0.10547f
C108 avdd.n34 avss 0.18366f
C109 avdd.n35 avss 0.01815f
C110 avdd.n36 avss 0.01035f
C111 avdd.n37 avss 0.00225f
C112 avdd.n38 avss 0.00659f
C113 avdd.n39 avss 0.01971f
C114 avdd.n40 avss 0.02726f
C115 A.n0 avss 0.05249f
C116 A.n1 avss 0.03245f
C117 A.n2 avss 0.18486f
C118 A.n3 avss 0.03276f
C119 A.n4 avss 0.20822f
C120 A.n5 avss 0.22524f
C121 A.n6 avss 0.09822f
C122 A.n7 avss 0.55004f
C123 B.n0 avss 0.38003f
C124 B.n1 avss 0.09371f
C125 B.n2 avss 0.41973f
C126 B avss -0.79128f
C127 avdd avss -1.76375f
C128 A avss -1.11939f
.ends
