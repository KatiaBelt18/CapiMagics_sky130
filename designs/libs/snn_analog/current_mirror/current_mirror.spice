* NGSPICE file created from current_mirror.ext - technology: sky130A

.subckt M3 w_n637_n635# a_n377_n200# a_n299_n396# a_n199_n200#
X0 a_n199_n200# a_n299_n396# a_n377_n200# w_n637_n635# sky130_fd_pr__pfet_01v8 ad=0.33 pd=2.33 as=0.78 ps=4.78 w=2 l=0.5
X1 a_n377_n200# a_n299_n396# a_n199_n200# w_n637_n635# sky130_fd_pr__pfet_01v8 ad=0.78 pd=4.78 as=0.33 ps=2.33 w=2 l=0.5
X2 a_n199_n200# a_n299_n396# a_n377_n200# w_n637_n635# sky130_fd_pr__pfet_01v8 ad=0.33 pd=2.33 as=0.33 ps=2.33 w=2 l=0.5
X3 a_n377_n200# a_n299_n396# a_n199_n200# w_n637_n635# sky130_fd_pr__pfet_01v8 ad=0.33 pd=2.33 as=0.33 ps=2.33 w=2 l=0.5
.ends

.subckt M1 a_n167_n200# a_n33_n200# a_n89_n396# a_n381_n589#
X0 a_n33_n200# a_n89_n396# a_n167_n200# a_n381_n589# sky130_fd_pr__nfet_01v8 ad=0.33 pd=2.33 as=0.78 ps=4.78 w=2 l=0.28
X1 a_n167_n200# a_n89_n396# a_n33_n200# a_n381_n589# sky130_fd_pr__nfet_01v8 ad=0.78 pd=4.78 as=0.33 ps=2.33 w=2 l=0.28
.ends

.subckt M4 w_n388_n595# a_n50_n358# a_n128_n160# a_50_n160#
X0 a_50_n160# a_n50_n358# a_n128_n160# w_n388_n595# sky130_fd_pr__pfet_01v8 ad=0.624 pd=3.98 as=0.624 ps=3.98 w=1.6 l=0.5
.ends

.subckt M2 a_n833_n396# a_n33_n200# a_n1125_n589# a_n911_n200#
X0 a_n33_n200# a_n833_n396# a_n911_n200# a_n1125_n589# sky130_fd_pr__nfet_01v8 ad=0.33 pd=2.33 as=0.78 ps=4.78 w=2 l=4
X1 a_n911_n200# a_n833_n396# a_n33_n200# a_n1125_n589# sky130_fd_pr__nfet_01v8 ad=0.78 pd=4.78 as=0.33 ps=2.33 w=2 l=4
.ends

.subckt current_mirror avdd avss B A
XM3_0 avdd avdd B B M3
XM1_0 avss A A avss M1
XM4_0 avdd A avdd A M4
XM2_0 A B avss avss M2
.ends
