* NGSPICE file created from encoder.ext - technology: gf180mcuD

.subckt xm5 a_n306_n173# a_186_n173# w_n572_n603# a_n186_n382# VSUBS
X0 a_186_n173# a_n186_n382# a_n306_n173# w_n572_n603# pfet_03v3 ad=0.558p pd=3.06u as=0.558p ps=3.06u w=0.93u l=1.86u

C0 a_186_n173# w_n572_n603# 0.66931f
C1 a_n186_n382# a_n306_n173# 0.11626f
C2 a_n306_n173# w_n572_n603# 0.29685f
C3 a_186_n173# a_n306_n173# 0.38397f
C4 a_n186_n382# w_n572_n603# 0.94238f
C5 a_186_n173# a_n186_n382# 0.05372f

C0 a_186_n173# w_n572_n603# 0.66931f
C1 a_n186_n382# a_n306_n173# 0.11626f
C2 a_n306_n173# w_n572_n603# 0.29685f
C3 a_n186_n382# w_n572_n603# 0.94238f
C4 a_186_n173# a_n306_n173# 0.38397f
C5 a_186_n173# a_n186_n382# 0.05372f

C0 a_n306_n173# a_186_n173# 0.38397f
C1 a_n186_n382# w_n572_n603# 0.94238f
C2 a_n186_n382# a_n306_n173# 0.11626f
C3 a_n186_n382# a_186_n173# 0.05372f
C4 a_n306_n173# w_n572_n603# 0.29685f
C5 a_186_n173# w_n572_n603# 0.66931f

C6 a_186_n173# VSUBS 0.04839f
C7 a_n306_n173# VSUBS 0.04832f
C8 a_n186_n382# VSUBS 0.07458f
C9 w_n572_n603# VSUBS 5.08511f
.ends

.subckt xm3 a_28_n281# a_n178_n281# w_n444_n709# a_n50_n489# VSUBS
X0 a_28_n281# a_n50_n489# a_n178_n281# w_n444_n709# pfet_03v3 ad=1.5p pd=5.5u as=1.5p ps=5.5u w=2u l=0.28u

C0 a_28_n281# w_n444_n709# 0.6139f
C1 a_n50_n489# a_n178_n281# 0.0391f
C2 a_n178_n281# w_n444_n709# 0.35562f
C3 a_28_n281# a_n178_n281# 0.53377f
C4 a_n50_n489# w_n444_n709# 0.38939f
C5 a_28_n281# a_n50_n489# 0.02705f
C0 a_28_n281# w_n444_n709# 0.6139f
C1 a_n50_n489# a_n178_n281# 0.0391f
C2 a_n178_n281# w_n444_n709# 0.35562f
C3 a_n50_n489# w_n444_n709# 0.38939f
C4 a_28_n281# a_n178_n281# 0.53377f
C5 a_28_n281# a_n50_n489# 0.02705f
C0 a_n178_n281# a_28_n281# 0.53377f
C1 a_n50_n489# w_n444_n709# 0.38939f
C2 a_n50_n489# a_n178_n281# 0.0391f
C3 a_n50_n489# a_28_n281# 0.02705f
C4 a_n178_n281# w_n444_n709# 0.35562f
C5 a_28_n281# w_n444_n709# 0.6139f
C6 a_28_n281# VSUBS 0.08168f
C7 a_n178_n281# VSUBS 0.08054f
C8 a_n50_n489# VSUBS 0.0484f
C9 w_n444_n709# VSUBS 4.62248f
.ends

.subckt xm11 a_n178_n131# a_n50_n339# w_n444_n560# a_28_n131# VSUBS
X0 a_28_n131# a_n50_n339# a_n178_n131# w_n444_n560# pfet_03v3 ad=0.375p pd=2.5u as=0.375p ps=2.5u w=0.5u l=0.28u

C0 a_28_n131# w_n444_n560# 0.48499f
C1 a_n50_n339# a_n178_n131# 0.02611f
C2 a_n178_n131# w_n444_n560# 0.22952f
C3 a_28_n131# a_n178_n131# 0.34063f
C4 a_n50_n339# w_n444_n560# 0.39308f
C5 a_28_n131# a_n50_n339# 0.01004f

C0 a_28_n131# w_n444_n560# 0.48499f
C1 a_n50_n339# a_n178_n131# 0.02611f
C2 a_n178_n131# w_n444_n560# 0.22952f
C3 a_n50_n339# w_n444_n560# 0.39308f
C4 a_28_n131# a_n178_n131# 0.34063f
C5 a_28_n131# a_n50_n339# 0.01004f

C0 a_n178_n131# a_28_n131# 0.34063f
C1 a_n50_n339# w_n444_n560# 0.39308f
C2 a_n50_n339# a_n178_n131# 0.02611f
C3 a_n50_n339# a_28_n131# 0.01004f
C4 a_n178_n131# w_n444_n560# 0.22952f
C5 a_28_n131# w_n444_n560# 0.48499f
C6 a_28_n131# VSUBS 0.04441f
C7 a_n178_n131# VSUBS 0.04328f
C8 a_n50_n339# VSUBS 0.04859f
C9 w_n444_n560# VSUBS 3.73985f
.ends

.subckt xm1 a_n1120_n131# a_n1330_n504# a_1000_n131# a_n1000_n339#
X0 a_1000_n131# a_n1000_n339# a_n1120_n131# a_n1330_n504# nfet_03v3 ad=0.3p pd=2.2u as=0.3p ps=2.2u w=0.5u l=10u
C0 a_n1120_n131# a_1000_n131# 1.01551f
C1 a_1000_n131# a_n1000_n339# 0.06176f
C2 a_n1120_n131# a_n1000_n339# 0.42273f
C0 a_n1120_n131# a_1000_n131# 1.01551f
C1 a_1000_n131# a_n1000_n339# 0.06176f
C2 a_n1120_n131# a_n1000_n339# 0.42273f
C0 a_n1120_n131# a_n1000_n339# 0.42273f
C1 a_n1120_n131# a_1000_n131# 1.01551f
C2 a_1000_n131# a_n1000_n339# 0.06176f
C3 a_1000_n131# a_n1330_n504# 1.43795f
C4 a_n1120_n131# a_n1330_n504# 0.4423f
C5 a_n1000_n339# a_n1330_n504# 4.53847f
.ends

.subckt xm8 a_n306_n173# a_186_n173# w_n572_n603# a_n186_n382# VSUBS
X0 a_186_n173# a_n186_n382# a_n306_n173# w_n572_n603# pfet_03v3 ad=0.558p pd=3.06u as=0.558p ps=3.06u w=0.93u l=1.86u
C0 a_186_n173# w_n572_n603# 0.66931f
C1 a_n186_n382# a_n306_n173# 0.11626f
C2 a_n306_n173# w_n572_n603# 0.29685f
C3 a_186_n173# a_n306_n173# 0.38397f
C4 a_n186_n382# w_n572_n603# 0.94238f
C5 a_186_n173# a_n186_n382# 0.05372f
C0 a_186_n173# w_n572_n603# 0.66931f
C1 a_n186_n382# a_n306_n173# 0.11626f
C2 a_n306_n173# w_n572_n603# 0.29685f
C3 a_n186_n382# w_n572_n603# 0.94238f
C4 a_186_n173# a_n306_n173# 0.38397f
C5 a_186_n173# a_n186_n382# 0.05372f
C0 a_n306_n173# a_186_n173# 0.38397f
C1 a_n186_n382# w_n572_n603# 0.94238f
C2 a_n186_n382# a_n306_n173# 0.11626f
C3 a_n186_n382# a_186_n173# 0.05372f
C4 a_n306_n173# w_n572_n603# 0.29685f
C5 a_186_n173# w_n572_n603# 0.66931f
C6 a_186_n173# VSUBS 0.04839f
C7 a_n306_n173# VSUBS 0.04832f
C8 a_n186_n382# VSUBS 0.07458f
C9 w_n572_n603# VSUBS 5.08511f
.ends

.subckt xm6 a_n306_n173# a_186_n173# w_n572_n603# a_n186_n382# VSUBS
X0 a_186_n173# a_n186_n382# a_n306_n173# w_n572_n603# pfet_03v3 ad=0.558p pd=3.06u as=0.558p ps=3.06u w=0.93u l=1.86u
C0 a_186_n173# w_n572_n603# 0.66931f
C1 a_n186_n382# a_n306_n173# 0.11626f
C2 a_n306_n173# w_n572_n603# 0.29685f
C3 a_186_n173# a_n306_n173# 0.38397f
C4 a_n186_n382# w_n572_n603# 0.94238f
C5 a_186_n173# a_n186_n382# 0.05372f
C0 a_186_n173# w_n572_n603# 0.66931f
C1 a_n186_n382# a_n306_n173# 0.11626f
C2 a_n306_n173# w_n572_n603# 0.29685f
C3 a_n186_n382# w_n572_n603# 0.94238f
C4 a_186_n173# a_n306_n173# 0.38397f
C5 a_186_n173# a_n186_n382# 0.05372f
C0 a_n306_n173# a_186_n173# 0.38397f
C1 a_n186_n382# w_n572_n603# 0.94238f
C2 a_n186_n382# a_n306_n173# 0.11626f
C3 a_n186_n382# a_186_n173# 0.05372f
C4 a_n306_n173# w_n572_n603# 0.29685f
C5 a_186_n173# w_n572_n603# 0.66931f
C6 a_186_n173# VSUBS 0.04839f
C7 a_n306_n173# VSUBS 0.04832f
C8 a_n186_n382# VSUBS 0.07458f
C9 w_n572_n603# VSUBS 5.08511f
.ends

.subckt xm4 a_28_n281# a_n178_n281# w_n444_n709# a_n50_n489# VSUBS
X0 a_28_n281# a_n50_n489# a_n178_n281# w_n444_n709# pfet_03v3 ad=1.5p pd=5.5u as=1.5p ps=5.5u w=2u l=0.28u
C0 a_28_n281# w_n444_n709# 0.6139f
C1 a_n50_n489# a_n178_n281# 0.0391f
C2 a_n178_n281# w_n444_n709# 0.35562f
C3 a_28_n281# a_n178_n281# 0.53377f
C4 a_n50_n489# w_n444_n709# 0.38939f
C5 a_28_n281# a_n50_n489# 0.02705f
C0 a_28_n281# w_n444_n709# 0.6139f
C1 a_n50_n489# a_n178_n281# 0.0391f
C2 a_n178_n281# w_n444_n709# 0.35562f
C3 a_n50_n489# w_n444_n709# 0.38939f
C4 a_28_n281# a_n178_n281# 0.53377f
C5 a_28_n281# a_n50_n489# 0.02705f
C0 a_n178_n281# a_28_n281# 0.53377f
C1 a_n50_n489# w_n444_n709# 0.38939f
C2 a_n50_n489# a_n178_n281# 0.0391f
C3 a_n50_n489# a_28_n281# 0.02705f
C4 a_n178_n281# w_n444_n709# 0.35562f
C5 a_28_n281# w_n444_n709# 0.6139f
C6 a_28_n281# VSUBS 0.08168f
C7 a_n178_n281# VSUBS 0.08054f
C8 a_n50_n489# VSUBS 0.0484f
C9 w_n444_n709# VSUBS 4.62248f
.ends

.subckt xm2 a_n1120_n131# a_n1330_n504# a_1000_n131# a_n1000_n339#
X0 a_1000_n131# a_n1000_n339# a_n1120_n131# a_n1330_n504# nfet_03v3 ad=0.3p pd=2.2u as=0.3p ps=2.2u w=0.5u l=10u
C0 a_n1120_n131# a_1000_n131# 1.01551f
C1 a_1000_n131# a_n1000_n339# 0.06176f
C2 a_n1120_n131# a_n1000_n339# 0.42273f
C0 a_n1120_n131# a_1000_n131# 1.01551f
C1 a_1000_n131# a_n1000_n339# 0.06176f
C2 a_n1120_n131# a_n1000_n339# 0.42273f
C0 a_n1120_n131# a_n1000_n339# 0.42273f
C1 a_n1120_n131# a_1000_n131# 1.01551f
C2 a_1000_n131# a_n1000_n339# 0.06176f
C3 a_1000_n131# a_n1330_n504# 1.43795f
C4 a_n1120_n131# a_n1330_n504# 0.4423f
C5 a_n1000_n339# a_n1330_n504# 4.53847f
.ends

.subckt xm10 a_n178_n131# a_n50_n339# a_n388_n504# a_28_n131#
X0 a_28_n131# a_n50_n339# a_n178_n131# a_n388_n504# nfet_03v3 ad=0.375p pd=2.5u as=0.375p ps=2.5u w=0.5u l=0.28u
C0 a_n178_n131# a_28_n131# 0.34063f
C1 a_28_n131# a_n50_n339# 0.01004f
C2 a_n178_n131# a_n50_n339# 0.02611f
C0 a_n178_n131# a_28_n131# 0.34063f
C1 a_28_n131# a_n50_n339# 0.01004f
C2 a_n178_n131# a_n50_n339# 0.02611f
C0 a_n178_n131# a_n50_n339# 0.02611f
C1 a_n178_n131# a_28_n131# 0.34063f
C2 a_28_n131# a_n50_n339# 0.01004f
C3 a_28_n131# a_n388_n504# 0.52938f
C4 a_n178_n131# a_n388_n504# 0.27279f
C5 a_n50_n339# a_n388_n504# 0.44167f
.ends

.subckt xm9 a_n178_n131# a_n50_n339# a_n388_n504# a_28_n131#
X0 a_28_n131# a_n50_n339# a_n178_n131# a_n388_n504# nfet_03v3 ad=0.375p pd=2.5u as=0.375p ps=2.5u w=0.5u l=0.28u
C0 a_n178_n131# a_28_n131# 0.34063f
C1 a_28_n131# a_n50_n339# 0.01004f
C2 a_n178_n131# a_n50_n339# 0.02611f
C0 a_n178_n131# a_28_n131# 0.34063f
C1 a_28_n131# a_n50_n339# 0.01004f
C2 a_n178_n131# a_n50_n339# 0.02611f
C0 a_n178_n131# a_n50_n339# 0.02611f
C1 a_n178_n131# a_28_n131# 0.34063f
C2 a_28_n131# a_n50_n339# 0.01004f
C3 a_28_n131# a_n388_n504# 0.52938f
C4 a_n178_n131# a_n388_n504# 0.27279f
C5 a_n50_n339# a_n388_n504# 0.44167f
.ends

.subckt xm7 a_n306_n173# a_186_n173# w_n572_n603# a_n186_n382# VSUBS
X0 a_186_n173# a_n186_n382# a_n306_n173# w_n572_n603# pfet_03v3 ad=0.558p pd=3.06u as=0.558p ps=3.06u w=0.93u l=1.86u
C0 a_186_n173# w_n572_n603# 0.66931f
C1 a_n186_n382# a_n306_n173# 0.11626f
C2 a_n306_n173# w_n572_n603# 0.29685f
C3 a_186_n173# a_n306_n173# 0.38397f
C4 a_n186_n382# w_n572_n603# 0.94238f
C5 a_186_n173# a_n186_n382# 0.05372f
C0 a_186_n173# w_n572_n603# 0.66931f
C1 a_n186_n382# a_n306_n173# 0.11626f
C2 a_n306_n173# w_n572_n603# 0.29685f
C3 a_n186_n382# w_n572_n603# 0.94238f
C4 a_186_n173# a_n306_n173# 0.38397f
C5 a_186_n173# a_n186_n382# 0.05372f
C0 a_n306_n173# a_186_n173# 0.38397f
C1 a_n186_n382# w_n572_n603# 0.94238f
C2 a_n186_n382# a_n306_n173# 0.11626f
C3 a_n186_n382# a_186_n173# 0.05372f
C4 a_n306_n173# w_n572_n603# 0.29685f
C5 a_186_n173# w_n572_n603# 0.66931f
C6 a_186_n173# VSUBS 0.04839f
C7 a_n306_n173# VSUBS 0.04832f
C8 a_n186_n382# VSUBS 0.07458f
C9 w_n572_n603# VSUBS 5.08511f
.ends

.subckt encoder Vdd Vss Vin Vin_neg Iex_1_i Iex_2_i Iex_3_i Iex_4_i
Xxm5_0 Vdd Iex_2_i Vdd xm3_0/a_28_n281# Vss xm5
Xxm3_0 xm3_0/a_28_n281# Vdd Vdd xm3_0/a_28_n281# Vss xm3
Xxm11_0 Vdd xm9_0/a_n50_n339# Vdd xm9_0/a_n50_n339# Vss xm11
Xxm1_0 xm9_0/a_28_n131# Vss xm3_0/a_28_n281# Vin xm1
Xxm8_0 Vdd Iex_1_i Vdd xm3_0/a_28_n281# Vss xm8
Xxm6_0 Vdd Iex_4_i Vdd xm4_0/a_28_n281# Vss xm6
Xxm4_0 xm4_0/a_28_n281# Vdd Vdd xm4_0/a_28_n281# Vss xm4
Xxm2_0 xm9_0/a_28_n131# Vss xm4_0/a_28_n281# Vin_neg xm2
Xxm10_0 Vss xm9_0/a_n50_n339# Vss xm9_0/a_n50_n339# xm10
Xxm9_0 Vss xm9_0/a_n50_n339# Vss xm9_0/a_28_n131# xm9
Xxm7_0 Vdd Iex_3_i Vdd xm4_0/a_28_n281# Vss xm7
R0 Vin_neg Vin_neg.n0 9.84231
R1 Vin Vin.n0 9.84231
R0 Vin_neg Vin_neg.n0 5.34237
R1 Vin Vin.n0 5.34231
R2 Vss.n213 Vss.n173 16945.1
R3 Vss.n123 Vss.n122 11700.7
R4 Vss.n123 Vss.n18 10887.5
R5 Vss.n223 Vss.n173 10887.5
R6 Vss.n172 Vss.n138 10887.5
R7 Vss.n256 Vss.n125 10111.1
R8 Vss.n124 Vss.n17 10111.1
R9 Vss.n173 Vss.n172 4830.04
R10 Vss.n124 Vss.n123 4784.76
R11 Vss.n172 Vss.n125 4784.76
R12 Vss.n125 Vss.n124 3693.99
R13 Vss.n247 Vss.n246 793.182
R14 Vss.n41 Vss.n17 577.389
R15 Vss.n257 Vss.n256 577.389
R16 Vss.n16 Vss.n7 396.591
R17 Vss.n258 Vss.n257 396.591
R18 Vss.n255 Vss.n126 396.591
R19 Vss.n248 Vss.n247 396.591
R20 Vss.n122 Vss.n19 370.346
R21 Vss.n97 Vss.n41 370.346
R22 Vss.n214 Vss.n213 370.346
R23 Vss.n63 Vss.n19 233.288
R24 Vss.n64 Vss.n63 233.288
R25 Vss.n66 Vss.n64 233.288
R26 Vss.n66 Vss.n53 233.288
R27 Vss.n74 Vss.n53 233.288
R28 Vss.n75 Vss.n74 233.288
R29 Vss.n77 Vss.n75 233.288
R30 Vss.n85 Vss.n47 233.288
R31 Vss.n86 Vss.n85 233.288
R32 Vss.n88 Vss.n86 233.288
R33 Vss.n88 Vss.n40 233.288
R34 Vss.n97 Vss.n40 233.288
R35 Vss.n258 Vss.n7 233.288
R36 Vss.n248 Vss.n126 233.288
R37 Vss.n148 Vss.n147 233.288
R38 Vss.n238 Vss.n148 233.288
R39 Vss.n238 Vss.n149 233.288
R40 Vss.n232 Vss.n149 233.288
R41 Vss.n232 Vss.n231 233.288
R42 Vss.n231 Vss.n230 233.288
R43 Vss.n230 Vss.n163 233.288
R44 Vss.n224 Vss.n163 233.288
R45 Vss.n222 Vss.n221 233.288
R46 Vss.n221 Vss.n176 233.288
R47 Vss.n215 Vss.n176 233.288
R48 Vss.n215 Vss.n214 233.288
R49 Vss.n17 Vss.n16 215.792
R50 Vss.n256 Vss.n255 215.792
R51 Vss.n147 Vss.n138 212.876
R52 Vss.n246 Vss.n138 157.47
R53 Vss.n77 Vss.n18 154.554
R54 Vss.n223 Vss.n222 119.561
R55 Vss.n224 Vss.n223 113.728
R56 Vss.n47 Vss.n18 78.7354
R57 Vss.n137 Vss.n131 68.4449
R58 Vss.n249 Vss.n131 68.4449
R59 Vss.n254 Vss.n128 68.4449
R60 Vss.n254 Vss.n127 68.4449
R61 Vss.n8 Vss.n6 68.4449
R62 Vss.n259 Vss.n6 68.4449
R63 Vss.n15 Vss.n5 68.4449
R64 Vss.n15 Vss.n9 68.4449
R65 Vss.n245 Vss.n139 66.6949
R66 Vss.n212 Vss.n183 66.6949
R67 Vss.n212 Vss.n185 66.6949
R68 Vss.n245 Vss.n140 66.6949
R69 Vss.n121 Vss.n20 66.6949
R70 Vss.n121 Vss.n21 66.6949
R71 Vss.n96 Vss.n39 66.6949
R72 Vss.n98 Vss.n39 66.6949
R73 Vss.n150 Vss.n139 15.5561
R74 Vss.n237 Vss.n150 15.5561
R75 Vss.n237 Vss.n151 15.5561
R76 Vss.n233 Vss.n151 15.5561
R77 Vss.n233 Vss.n159 15.5561
R78 Vss.n229 Vss.n159 15.5561
R79 Vss.n229 Vss.n164 15.5561
R80 Vss.n225 Vss.n164 15.5561
R81 Vss.n225 Vss.n170 15.5561
R82 Vss.n220 Vss.n170 15.5561
R83 Vss.n220 Vss.n177 15.5561
R84 Vss.n216 Vss.n177 15.5561
R85 Vss.n216 Vss.n183 15.5561
R86 Vss.n143 Vss.n140 15.5561
R87 Vss.n239 Vss.n143 15.5561
R88 Vss.n239 Vss.n146 15.5561
R89 Vss.n160 Vss.n146 15.5561
R90 Vss.n161 Vss.n160 15.5561
R91 Vss.n162 Vss.n161 15.5561
R92 Vss.n198 Vss.n162 15.5561
R93 Vss.n198 Vss.n171 15.5561
R94 Vss.n174 Vss.n171 15.5561
R95 Vss.n175 Vss.n174 15.5561
R96 Vss.n205 Vss.n175 15.5561
R97 Vss.n205 Vss.n184 15.5561
R98 Vss.n185 Vss.n184 15.5561
R99 Vss.n249 Vss.n128 15.5561
R100 Vss.n137 Vss.n127 15.5561
R101 Vss.n259 Vss.n5 15.5561
R102 Vss.n9 Vss.n8 15.5561
R103 Vss.n62 Vss.n20 15.5561
R104 Vss.n62 Vss.n58 15.5561
R105 Vss.n67 Vss.n58 15.5561
R106 Vss.n67 Vss.n54 15.5561
R107 Vss.n73 Vss.n54 15.5561
R108 Vss.n73 Vss.n52 15.5561
R109 Vss.n78 Vss.n52 15.5561
R110 Vss.n78 Vss.n48 15.5561
R111 Vss.n84 Vss.n48 15.5561
R112 Vss.n84 Vss.n46 15.5561
R113 Vss.n89 Vss.n46 15.5561
R114 Vss.n89 Vss.n42 15.5561
R115 Vss.n96 Vss.n42 15.5561
R116 Vss.n24 Vss.n21 15.5561
R117 Vss.n25 Vss.n24 15.5561
R118 Vss.n65 Vss.n25 15.5561
R119 Vss.n65 Vss.n28 15.5561
R120 Vss.n29 Vss.n28 15.5561
R121 Vss.n30 Vss.n29 15.5561
R122 Vss.n76 Vss.n30 15.5561
R123 Vss.n76 Vss.n33 15.5561
R124 Vss.n34 Vss.n33 15.5561
R125 Vss.n35 Vss.n34 15.5561
R126 Vss.n87 Vss.n35 15.5561
R127 Vss.n87 Vss.n38 15.5561
R128 Vss.n98 Vss.n38 15.5561
R129 Vss.n210 Vss.n1 6.4812
R130 Vss.n264 Vss.n0 5.529
R129 Vss.n210 Vss.n1 6.43229
R130 Vss Vss.n0 5.48009
R131 Vss.n11 Vss.n8 5.2005
R132 Vss.n258 Vss.n8 5.2005
R133 Vss.n12 Vss.n9 5.2005
R134 Vss.n9 Vss.n7 5.2005
R135 Vss.n260 Vss.n259 5.2005
R136 Vss.n259 Vss.n258 5.2005
R137 Vss.n5 Vss.n4 5.2005
R138 Vss.n7 Vss.n5 5.2005
R139 Vss.n137 Vss.n136 5.2005
R140 Vss.n248 Vss.n137 5.2005
R141 Vss.n132 Vss.n127 5.2005
R142 Vss.n127 Vss.n126 5.2005
R143 Vss.n250 Vss.n249 5.2005
R144 Vss.n249 Vss.n248 5.2005
R145 Vss.n251 Vss.n128 5.2005
R146 Vss.n128 Vss.n126 5.2005
R147 Vss.n208 Vss.n185 5.2005
R148 Vss.n214 Vss.n185 5.2005
R149 Vss.n207 Vss.n184 5.2005
R150 Vss.n215 Vss.n184 5.2005
R151 Vss.n206 Vss.n205 5.2005
R152 Vss.n205 Vss.n176 5.2005
R153 Vss.n188 Vss.n175 5.2005
R154 Vss.n221 Vss.n175 5.2005
R155 Vss.n201 Vss.n174 5.2005
R156 Vss.n222 Vss.n174 5.2005
R157 Vss.n200 Vss.n171 5.2005
R158 Vss.n224 Vss.n171 5.2005
R159 Vss.n199 Vss.n198 5.2005
R160 Vss.n198 Vss.n163 5.2005
R161 Vss.n190 Vss.n162 5.2005
R162 Vss.n230 Vss.n162 5.2005
R163 Vss.n194 Vss.n161 5.2005
R164 Vss.n231 Vss.n161 5.2005
R165 Vss.n193 Vss.n160 5.2005
R166 Vss.n232 Vss.n160 5.2005
R167 Vss.n146 Vss.n145 5.2005
R168 Vss.n149 Vss.n146 5.2005
R169 Vss.n240 Vss.n239 5.2005
R170 Vss.n239 Vss.n238 5.2005
R171 Vss.n241 Vss.n143 5.2005
R172 Vss.n148 Vss.n143 5.2005
R173 Vss.n242 Vss.n140 5.2005
R174 Vss.n147 Vss.n140 5.2005
R175 Vss.n152 Vss.n139 5.2005
R176 Vss.n147 Vss.n139 5.2005
R177 Vss.n153 Vss.n150 5.2005
R178 Vss.n150 Vss.n148 5.2005
R179 Vss.n237 Vss.n236 5.2005
R180 Vss.n238 Vss.n237 5.2005
R181 Vss.n235 Vss.n151 5.2005
R182 Vss.n151 Vss.n149 5.2005
R183 Vss.n234 Vss.n233 5.2005
R184 Vss.n233 Vss.n232 5.2005
R185 Vss.n159 Vss.n158 5.2005
R186 Vss.n231 Vss.n159 5.2005
R187 Vss.n229 Vss.n228 5.2005
R188 Vss.n230 Vss.n229 5.2005
R189 Vss.n227 Vss.n164 5.2005
R190 Vss.n164 Vss.n163 5.2005
R191 Vss.n226 Vss.n225 5.2005
R192 Vss.n225 Vss.n224 5.2005
R193 Vss.n170 Vss.n169 5.2005
R194 Vss.n222 Vss.n170 5.2005
R195 Vss.n220 Vss.n219 5.2005
R196 Vss.n221 Vss.n220 5.2005
R197 Vss.n218 Vss.n177 5.2005
R198 Vss.n177 Vss.n176 5.2005
R199 Vss.n217 Vss.n216 5.2005
R200 Vss.n216 Vss.n215 5.2005
R201 Vss.n183 Vss.n182 5.2005
R202 Vss.n214 Vss.n183 5.2005
R203 Vss.n96 Vss.n95 5.2005
R204 Vss.n97 Vss.n96 5.2005
R205 Vss.n43 Vss.n42 5.2005
R206 Vss.n42 Vss.n40 5.2005
R207 Vss.n90 Vss.n89 5.2005
R208 Vss.n89 Vss.n88 5.2005
R209 Vss.n46 Vss.n45 5.2005
R210 Vss.n86 Vss.n46 5.2005
R211 Vss.n84 Vss.n83 5.2005
R212 Vss.n85 Vss.n84 5.2005
R213 Vss.n49 Vss.n48 5.2005
R214 Vss.n48 Vss.n47 5.2005
R215 Vss.n79 Vss.n78 5.2005
R216 Vss.n78 Vss.n77 5.2005
R217 Vss.n52 Vss.n51 5.2005
R218 Vss.n75 Vss.n52 5.2005
R219 Vss.n73 Vss.n72 5.2005
R220 Vss.n74 Vss.n73 5.2005
R221 Vss.n55 Vss.n54 5.2005
R222 Vss.n54 Vss.n53 5.2005
R223 Vss.n68 Vss.n67 5.2005
R224 Vss.n67 Vss.n66 5.2005
R225 Vss.n58 Vss.n57 5.2005
R226 Vss.n64 Vss.n58 5.2005
R227 Vss.n62 Vss.n61 5.2005
R228 Vss.n63 Vss.n62 5.2005
R229 Vss.n59 Vss.n20 5.2005
R230 Vss.n20 Vss.n19 5.2005
R231 Vss.n99 Vss.n98 5.2005
R232 Vss.n98 Vss.n97 5.2005
R233 Vss.n100 Vss.n38 5.2005
R234 Vss.n40 Vss.n38 5.2005
R235 Vss.n87 Vss.n36 5.2005
R236 Vss.n88 Vss.n87 5.2005
R237 Vss.n104 Vss.n35 5.2005
R238 Vss.n86 Vss.n35 5.2005
R239 Vss.n105 Vss.n34 5.2005
R240 Vss.n85 Vss.n34 5.2005
R241 Vss.n106 Vss.n33 5.2005
R242 Vss.n47 Vss.n33 5.2005
R243 Vss.n76 Vss.n31 5.2005
R244 Vss.n77 Vss.n76 5.2005
R245 Vss.n110 Vss.n30 5.2005
R246 Vss.n75 Vss.n30 5.2005
R247 Vss.n111 Vss.n29 5.2005
R248 Vss.n74 Vss.n29 5.2005
R249 Vss.n112 Vss.n28 5.2005
R250 Vss.n53 Vss.n28 5.2005
R251 Vss.n65 Vss.n26 5.2005
R252 Vss.n66 Vss.n65 5.2005
R253 Vss.n116 Vss.n25 5.2005
R254 Vss.n64 Vss.n25 5.2005
R255 Vss.n117 Vss.n24 5.2005
R256 Vss.n63 Vss.n24 5.2005
R257 Vss.n118 Vss.n21 5.2005
R258 Vss.n21 Vss.n19 5.2005
R259 Vss.n135 Vss.n134 5.19561
R260 Vss.n253 Vss.n252 5.19561
R261 Vss.n10 Vss.n2 5.19561
R262 Vss.n14 Vss.n3 5.19561
R263 Vss.n253 Vss.n129 5.18779
R264 Vss.n14 Vss.n13 5.18779
R265 Vss.n244 Vss.n141 5.17941
R266 Vss.n211 Vss.n186 5.17941
R267 Vss.n244 Vss.n243 5.17941
R268 Vss.n120 Vss.n119 5.17941
R269 Vss.n120 Vss.n22 5.17941
R270 Vss.n94 Vss.n93 5.17941
R271 Vss.n133 Vss.n1 5.0718
R272 Vss.n263 Vss.n262 5.0718
R271 Vss.n133 Vss.n1 5.02289
R272 Vss.n263 Vss.n262 5.02289
R273 Vss.n133 Vss.n130 4.7417
R274 Vss.n262 Vss.n261 4.7417
R275 Vss.n210 Vss.n209 4.7255
R276 Vss.n37 Vss.n0 4.7255
R277 Vss.n152 Vss.n141 4.5005
R278 Vss.n154 Vss.n153 4.5005
R279 Vss.n236 Vss.n155 4.5005
R280 Vss.n235 Vss.n156 4.5005
R281 Vss.n234 Vss.n157 4.5005
R282 Vss.n165 Vss.n158 4.5005
R283 Vss.n228 Vss.n166 4.5005
R284 Vss.n227 Vss.n167 4.5005
R285 Vss.n226 Vss.n168 4.5005
R286 Vss.n178 Vss.n169 4.5005
R287 Vss.n219 Vss.n179 4.5005
R288 Vss.n218 Vss.n180 4.5005
R289 Vss.n217 Vss.n181 4.5005
R290 Vss.n186 Vss.n182 4.5005
R291 Vss.n241 Vss.n142 4.5005
R292 Vss.n240 Vss.n144 4.5005
R293 Vss.n191 Vss.n145 4.5005
R294 Vss.n193 Vss.n192 4.5005
R295 Vss.n195 Vss.n194 4.5005
R296 Vss.n196 Vss.n190 4.5005
R297 Vss.n199 Vss.n197 4.5005
R298 Vss.n200 Vss.n189 4.5005
R299 Vss.n202 Vss.n201 4.5005
R300 Vss.n203 Vss.n188 4.5005
R301 Vss.n206 Vss.n204 4.5005
R302 Vss.n207 Vss.n187 4.5005
R303 Vss.n209 Vss.n208 4.5005
R304 Vss.n243 Vss.n242 4.5005
R305 Vss.n250 Vss.n130 4.5005
R306 Vss.n252 Vss.n251 4.5005
R307 Vss.n136 Vss.n135 4.5005
R308 Vss.n132 Vss.n129 4.5005
R309 Vss.n261 Vss.n260 4.5005
R310 Vss.n4 Vss.n3 4.5005
R311 Vss.n11 Vss.n10 4.5005
R312 Vss.n13 Vss.n12 4.5005
R313 Vss.n117 Vss.n23 4.5005
R314 Vss.n116 Vss.n115 4.5005
R315 Vss.n114 Vss.n26 4.5005
R316 Vss.n113 Vss.n112 4.5005
R317 Vss.n111 Vss.n27 4.5005
R318 Vss.n110 Vss.n109 4.5005
R319 Vss.n108 Vss.n31 4.5005
R320 Vss.n107 Vss.n106 4.5005
R321 Vss.n105 Vss.n32 4.5005
R322 Vss.n104 Vss.n103 4.5005
R323 Vss.n102 Vss.n36 4.5005
R324 Vss.n101 Vss.n100 4.5005
R325 Vss.n99 Vss.n37 4.5005
R326 Vss.n119 Vss.n118 4.5005
R327 Vss.n61 Vss.n60 4.5005
R328 Vss.n57 Vss.n56 4.5005
R329 Vss.n69 Vss.n68 4.5005
R330 Vss.n70 Vss.n55 4.5005
R331 Vss.n72 Vss.n71 4.5005
R332 Vss.n51 Vss.n50 4.5005
R333 Vss.n80 Vss.n79 4.5005
R334 Vss.n81 Vss.n49 4.5005
R335 Vss.n83 Vss.n82 4.5005
R336 Vss.n45 Vss.n44 4.5005
R337 Vss.n91 Vss.n90 4.5005
R338 Vss.n92 Vss.n43 4.5005
R339 Vss.n95 Vss.n94 4.5005
R340 Vss.n59 Vss.n22 4.5005
<<<<<<< HEAD
R341 Vss Vss.n264 4.5005
R342 Vss.n15 Vss.n14 0.743357
R343 Vss.n16 Vss.n15 0.743357
R344 Vss.n6 Vss.n2 0.743357
R345 Vss.n257 Vss.n6 0.743357
R346 Vss.n254 Vss.n253 0.743357
R347 Vss.n255 Vss.n254 0.743357
R348 Vss.n134 Vss.n131 0.743357
R349 Vss.n247 Vss.n131 0.743357
R350 Vss.n245 Vss.n244 0.743357
R351 Vss.n246 Vss.n245 0.743357
R352 Vss.n212 Vss.n211 0.743357
R353 Vss.n213 Vss.n212 0.743357
R354 Vss.n121 Vss.n120 0.743357
R355 Vss.n122 Vss.n121 0.743357
R356 Vss.n93 Vss.n39 0.743357
R357 Vss.n41 Vss.n39 0.743357
R358 Vss.n263 Vss.n1 0.5621
R359 Vss.n211 Vss.n210 0.454413
R360 Vss.n134 Vss.n133 0.454413
R361 Vss.n262 Vss.n2 0.454413
R362 Vss.n93 Vss.n0 0.454413
R363 Vss.n242 Vss.n241 0.1445
R364 Vss.n241 Vss.n240 0.1445
R365 Vss.n240 Vss.n145 0.1445
R366 Vss.n193 Vss.n145 0.1445
R367 Vss.n194 Vss.n193 0.1445
R368 Vss.n194 Vss.n190 0.1445
R369 Vss.n199 Vss.n190 0.1445
R370 Vss.n200 Vss.n199 0.1445
R371 Vss.n201 Vss.n200 0.1445
R372 Vss.n201 Vss.n188 0.1445
R373 Vss.n206 Vss.n188 0.1445
R374 Vss.n207 Vss.n206 0.1445
R375 Vss.n208 Vss.n207 0.1445
R376 Vss.n153 Vss.n152 0.1445
R377 Vss.n236 Vss.n153 0.1445
R378 Vss.n236 Vss.n235 0.1445
R379 Vss.n235 Vss.n234 0.1445
R380 Vss.n234 Vss.n158 0.1445
R381 Vss.n228 Vss.n158 0.1445
R382 Vss.n228 Vss.n227 0.1445
R383 Vss.n227 Vss.n226 0.1445
R384 Vss.n226 Vss.n169 0.1445
R385 Vss.n219 Vss.n169 0.1445
R386 Vss.n219 Vss.n218 0.1445
R387 Vss.n218 Vss.n217 0.1445
R388 Vss.n217 Vss.n182 0.1445
R389 Vss.n154 Vss.n141 0.1445
R390 Vss.n155 Vss.n154 0.1445
R391 Vss.n156 Vss.n155 0.1445
R392 Vss.n157 Vss.n156 0.1445
R393 Vss.n165 Vss.n157 0.1445
R394 Vss.n166 Vss.n165 0.1445
R395 Vss.n167 Vss.n166 0.1445
R396 Vss.n168 Vss.n167 0.1445
R397 Vss.n178 Vss.n168 0.1445
R398 Vss.n179 Vss.n178 0.1445
R399 Vss.n180 Vss.n179 0.1445
R400 Vss.n181 Vss.n180 0.1445
R401 Vss.n186 Vss.n181 0.1445
R402 Vss.n243 Vss.n142 0.1445
R403 Vss.n144 Vss.n142 0.1445
R404 Vss.n191 Vss.n144 0.1445
R405 Vss.n192 Vss.n191 0.1445
R406 Vss.n195 Vss.n192 0.1445
R407 Vss.n196 Vss.n195 0.1445
R408 Vss.n197 Vss.n196 0.1445
R409 Vss.n197 Vss.n189 0.1445
R410 Vss.n202 Vss.n189 0.1445
R411 Vss.n203 Vss.n202 0.1445
R412 Vss.n204 Vss.n203 0.1445
R413 Vss.n204 Vss.n187 0.1445
R414 Vss.n209 Vss.n187 0.1445
R415 Vss.n251 Vss.n250 0.1445
R416 Vss.n252 Vss.n130 0.1445
R417 Vss.n135 Vss.n129 0.1445
R418 Vss.n136 Vss.n132 0.1445
R419 Vss.n260 Vss.n4 0.1445
R420 Vss.n261 Vss.n3 0.1445
R421 Vss.n13 Vss.n10 0.1445
R422 Vss.n12 Vss.n11 0.1445
R423 Vss.n61 Vss.n59 0.1445
R424 Vss.n61 Vss.n57 0.1445
R425 Vss.n68 Vss.n57 0.1445
R426 Vss.n68 Vss.n55 0.1445
R427 Vss.n72 Vss.n55 0.1445
R428 Vss.n72 Vss.n51 0.1445
R429 Vss.n79 Vss.n51 0.1445
R430 Vss.n79 Vss.n49 0.1445
R431 Vss.n83 Vss.n49 0.1445
R432 Vss.n83 Vss.n45 0.1445
R433 Vss.n90 Vss.n45 0.1445
R434 Vss.n90 Vss.n43 0.1445
R435 Vss.n95 Vss.n43 0.1445
R436 Vss.n118 Vss.n117 0.1445
R437 Vss.n117 Vss.n116 0.1445
R438 Vss.n116 Vss.n26 0.1445
R439 Vss.n112 Vss.n26 0.1445
R440 Vss.n112 Vss.n111 0.1445
R441 Vss.n111 Vss.n110 0.1445
R442 Vss.n110 Vss.n31 0.1445
R443 Vss.n106 Vss.n31 0.1445
R444 Vss.n106 Vss.n105 0.1445
R445 Vss.n105 Vss.n104 0.1445
R446 Vss.n104 Vss.n36 0.1445
R447 Vss.n100 Vss.n36 0.1445
R448 Vss.n100 Vss.n99 0.1445
R449 Vss.n119 Vss.n23 0.1445
R450 Vss.n115 Vss.n23 0.1445
R451 Vss.n115 Vss.n114 0.1445
R452 Vss.n114 Vss.n113 0.1445
R453 Vss.n113 Vss.n27 0.1445
R454 Vss.n109 Vss.n27 0.1445
R455 Vss.n109 Vss.n108 0.1445
R456 Vss.n108 Vss.n107 0.1445
R457 Vss.n107 Vss.n32 0.1445
R458 Vss.n103 Vss.n32 0.1445
R459 Vss.n103 Vss.n102 0.1445
R460 Vss.n102 Vss.n101 0.1445
R461 Vss.n101 Vss.n37 0.1445
R462 Vss.n60 Vss.n22 0.1445
R463 Vss.n60 Vss.n56 0.1445
R464 Vss.n69 Vss.n56 0.1445
R465 Vss.n70 Vss.n69 0.1445
R466 Vss.n71 Vss.n70 0.1445
R467 Vss.n71 Vss.n50 0.1445
R468 Vss.n80 Vss.n50 0.1445
R469 Vss.n81 Vss.n80 0.1445
R470 Vss.n82 Vss.n81 0.1445
R471 Vss.n82 Vss.n44 0.1445
R472 Vss.n91 Vss.n44 0.1445
R473 Vss.n92 Vss.n91 0.1445
R474 Vss.n94 Vss.n92 0.1445
R475 Vss.n264 Vss.n263 0.1013
R476 Vdd.n106 Vdd.n95 696.312
R477 Vdd.n106 Vdd.n105 696.312
R478 Vdd.n15 Vdd.n4 696.312
R479 Vdd.n7 Vdd.n4 696.312
R480 Vdd.n199 Vdd.n188 528.52
R481 Vdd.n191 Vdd.n188 528.52
R482 Vdd.n142 Vdd.n117 446.678
R483 Vdd.n127 Vdd.n117 446.678
R484 Vdd.n178 Vdd.n153 446.678
R485 Vdd.n163 Vdd.n153 446.678
R486 Vdd.n86 Vdd.n61 446.678
R487 Vdd.n71 Vdd.n61 446.678
R488 Vdd.n50 Vdd.n25 446.678
R489 Vdd.n35 Vdd.n25 446.678
R490 Vdd.n108 Vdd.n107 74.638
R491 Vdd.n107 Vdd.n96 74.638
R492 Vdd.n104 Vdd.n98 74.638
R493 Vdd.n98 Vdd.n97 74.638
R494 Vdd.n16 Vdd.n3 74.638
R495 Vdd.n8 Vdd.n3 74.638
R496 Vdd.n13 Vdd.n5 74.638
R497 Vdd.n14 Vdd.n13 74.638
R498 Vdd.n143 Vdd.n116 62.563
R499 Vdd.n129 Vdd.n116 62.563
R500 Vdd.n123 Vdd.n119 62.563
R501 Vdd.n141 Vdd.n119 62.563
R502 Vdd.n179 Vdd.n152 62.563
R503 Vdd.n165 Vdd.n152 62.563
R504 Vdd.n159 Vdd.n155 62.563
R505 Vdd.n177 Vdd.n155 62.563
R506 Vdd.n87 Vdd.n60 62.563
R507 Vdd.n73 Vdd.n60 62.563
R508 Vdd.n67 Vdd.n63 62.563
R509 Vdd.n85 Vdd.n63 62.563
R510 Vdd.n51 Vdd.n24 62.563
R511 Vdd.n37 Vdd.n24 62.563
R512 Vdd.n31 Vdd.n27 62.563
R513 Vdd.n49 Vdd.n27 62.563
R514 Vdd.n200 Vdd.n187 61.6005
R515 Vdd.n192 Vdd.n187 61.6005
R516 Vdd.n197 Vdd.n189 61.6005
R517 Vdd.n198 Vdd.n197 61.6005
R518 Vdd.n125 Vdd.n124 14.0005
R519 Vdd.n141 Vdd.n120 14.0005
R520 Vdd.n143 Vdd.n115 14.0005
R521 Vdd.n161 Vdd.n160 14.0005
R522 Vdd.n177 Vdd.n156 14.0005
R523 Vdd.n179 Vdd.n151 14.0005
R524 Vdd.n69 Vdd.n68 14.0005
R525 Vdd.n85 Vdd.n64 14.0005
R526 Vdd.n87 Vdd.n59 14.0005
R527 Vdd.n33 Vdd.n32 14.0005
R528 Vdd.n49 Vdd.n28 14.0005
R529 Vdd.n51 Vdd.n23 14.0005
R530 Vdd.n99 Vdd.n96 6.3005
R531 Vdd.n104 Vdd.n103 6.3005
R532 Vdd.n97 Vdd.n94 6.3005
R533 Vdd.n109 Vdd.n108 6.3005
R534 Vdd.n130 Vdd.n129 6.3005
R535 Vdd.n133 Vdd.n125 6.3005
R536 Vdd.n134 Vdd.n124 6.3005
R537 Vdd.n135 Vdd.n123 6.3005
R538 Vdd.n144 Vdd.n143 6.3005
R539 Vdd.n143 Vdd.n142 6.3005
R540 Vdd.n115 Vdd.n114 6.3005
R541 Vdd.n121 Vdd.n120 6.3005
R542 Vdd.n141 Vdd.n140 6.3005
R543 Vdd.n142 Vdd.n141 6.3005
R544 Vdd.n166 Vdd.n165 6.3005
R545 Vdd.n169 Vdd.n161 6.3005
R546 Vdd.n170 Vdd.n160 6.3005
R547 Vdd.n171 Vdd.n159 6.3005
R548 Vdd.n180 Vdd.n179 6.3005
R549 Vdd.n179 Vdd.n178 6.3005
R550 Vdd.n151 Vdd.n150 6.3005
R551 Vdd.n157 Vdd.n156 6.3005
R552 Vdd.n177 Vdd.n176 6.3005
R553 Vdd.n178 Vdd.n177 6.3005
R554 Vdd.n193 Vdd.n192 6.3005
R555 Vdd.n194 Vdd.n189 6.3005
R556 Vdd.n201 Vdd.n200 6.3005
R557 Vdd.n198 Vdd.n186 6.3005
R558 Vdd.n74 Vdd.n73 6.3005
R559 Vdd.n77 Vdd.n69 6.3005
R560 Vdd.n78 Vdd.n68 6.3005
R561 Vdd.n79 Vdd.n67 6.3005
R562 Vdd.n88 Vdd.n87 6.3005
R563 Vdd.n87 Vdd.n86 6.3005
R564 Vdd.n59 Vdd.n58 6.3005
R565 Vdd.n65 Vdd.n64 6.3005
R566 Vdd.n85 Vdd.n84 6.3005
R567 Vdd.n86 Vdd.n85 6.3005
R568 Vdd.n38 Vdd.n37 6.3005
R569 Vdd.n41 Vdd.n33 6.3005
R570 Vdd.n42 Vdd.n32 6.3005
R571 Vdd.n43 Vdd.n31 6.3005
R572 Vdd.n52 Vdd.n51 6.3005
R573 Vdd.n51 Vdd.n50 6.3005
R574 Vdd.n23 Vdd.n22 6.3005
R575 Vdd.n29 Vdd.n28 6.3005
R576 Vdd.n49 Vdd.n48 6.3005
R577 Vdd.n50 Vdd.n49 6.3005
R578 Vdd.n9 Vdd.n8 6.3005
R579 Vdd.n10 Vdd.n5 6.3005
R580 Vdd.n17 Vdd.n16 6.3005
R581 Vdd.n14 Vdd.n2 6.3005
R582 Vdd.n55 Vdd.n19 5.94426
R583 Vdd.n147 Vdd.n111 5.82906
R584 Vdd.n204 Vdd.n203 5.55898
R585 Vdd.n147 Vdd.n146 5.47485
R586 Vdd.n183 Vdd.n182 5.47485
R587 Vdd.n91 Vdd.n90 5.47485
R588 Vdd.n55 Vdd.n54 5.47485
R589 Vdd.n102 Vdd.n100 5.34137
R590 Vdd.n101 Vdd.n92 5.34137
R591 Vdd.n12 Vdd.n11 5.34137
R592 Vdd.n6 Vdd.n0 5.34137
R593 Vdd.n100 Vdd.n93 5.33355
R594 Vdd.n12 Vdd.n1 5.33355
R595 Vdd.n137 Vdd.n136 5.20888
R596 Vdd.n131 Vdd.n112 5.20888
R597 Vdd.n173 Vdd.n172 5.20888
R598 Vdd.n167 Vdd.n148 5.20888
R599 Vdd.n81 Vdd.n80 5.20888
R600 Vdd.n75 Vdd.n56 5.20888
R601 Vdd.n45 Vdd.n44 5.20888
R602 Vdd.n39 Vdd.n20 5.20888
R603 Vdd.n139 Vdd.n137 5.20105
R604 Vdd.n175 Vdd.n173 5.20105
R605 Vdd.n83 Vdd.n81 5.20105
R606 Vdd.n47 Vdd.n45 5.20105
R607 Vdd.n196 Vdd.n195 5.19561
R608 Vdd.n190 Vdd.n184 5.19561
R609 Vdd.n196 Vdd.n185 5.18779
R610 Vdd.n111 Vdd.n110 4.7417
R611 Vdd.n203 Vdd.n202 4.7417
R612 Vdd.n19 Vdd.n18 4.7417
R613 Vdd.n146 Vdd.n145 4.7129
R614 Vdd.n182 Vdd.n181 4.7129
R615 Vdd.n90 Vdd.n89 4.7129
R616 Vdd.n54 Vdd.n53 4.7129
R617 Vdd.n94 Vdd.n93 4.5005
R618 Vdd.n110 Vdd.n109 4.5005
R619 Vdd.n101 Vdd.n99 4.5005
R620 Vdd.n103 Vdd.n102 4.5005
R621 Vdd.n138 Vdd.n121 4.5005
R622 Vdd.n114 Vdd.n113 4.5005
R623 Vdd.n145 Vdd.n144 4.5005
R624 Vdd.n140 Vdd.n139 4.5005
R625 Vdd.n134 Vdd.n122 4.5005
R626 Vdd.n133 Vdd.n132 4.5005
R627 Vdd.n131 Vdd.n130 4.5005
R628 Vdd.n136 Vdd.n135 4.5005
R629 Vdd.n174 Vdd.n157 4.5005
R630 Vdd.n150 Vdd.n149 4.5005
R631 Vdd.n181 Vdd.n180 4.5005
R632 Vdd.n176 Vdd.n175 4.5005
R633 Vdd.n170 Vdd.n158 4.5005
R634 Vdd.n169 Vdd.n168 4.5005
R635 Vdd.n167 Vdd.n166 4.5005
R636 Vdd.n172 Vdd.n171 4.5005
R637 Vdd.n202 Vdd.n201 4.5005
R638 Vdd.n186 Vdd.n185 4.5005
R639 Vdd.n193 Vdd.n190 4.5005
R640 Vdd.n195 Vdd.n194 4.5005
R641 Vdd.n82 Vdd.n65 4.5005
R642 Vdd.n58 Vdd.n57 4.5005
R643 Vdd.n89 Vdd.n88 4.5005
R644 Vdd.n84 Vdd.n83 4.5005
R645 Vdd.n78 Vdd.n66 4.5005
R646 Vdd.n77 Vdd.n76 4.5005
R647 Vdd.n75 Vdd.n74 4.5005
R648 Vdd.n80 Vdd.n79 4.5005
R649 Vdd.n46 Vdd.n29 4.5005
R650 Vdd.n22 Vdd.n21 4.5005
R651 Vdd.n53 Vdd.n52 4.5005
R652 Vdd.n48 Vdd.n47 4.5005
R653 Vdd.n42 Vdd.n30 4.5005
R654 Vdd.n41 Vdd.n40 4.5005
R655 Vdd.n39 Vdd.n38 4.5005
R656 Vdd.n44 Vdd.n43 4.5005
R657 Vdd.n18 Vdd.n17 4.5005
R658 Vdd.n2 Vdd.n1 4.5005
R659 Vdd.n9 Vdd.n6 4.5005
R660 Vdd.n11 Vdd.n10 4.5005
R661 Vdd Vdd.n205 4.5005
R662 Vdd.n105 Vdd.n104 3.31679
R663 Vdd.n105 Vdd.n96 3.31679
R664 Vdd.n108 Vdd.n95 3.31679
R665 Vdd.n97 Vdd.n95 3.31679
R666 Vdd.n126 Vdd.n123 3.31679
R667 Vdd.n128 Vdd.n125 3.31679
R668 Vdd.n129 Vdd.n128 3.31679
R669 Vdd.n126 Vdd.n124 3.31679
R670 Vdd.n118 Vdd.n115 3.31679
R671 Vdd.n120 Vdd.n118 3.31679
R672 Vdd.n162 Vdd.n159 3.31679
R673 Vdd.n164 Vdd.n161 3.31679
R674 Vdd.n165 Vdd.n164 3.31679
R675 Vdd.n162 Vdd.n160 3.31679
R676 Vdd.n154 Vdd.n151 3.31679
R677 Vdd.n156 Vdd.n154 3.31679
R678 Vdd.n191 Vdd.n189 3.31679
R679 Vdd.n192 Vdd.n191 3.31679
R680 Vdd.n199 Vdd.n198 3.31679
R681 Vdd.n200 Vdd.n199 3.31679
R682 Vdd.n70 Vdd.n67 3.31679
R683 Vdd.n72 Vdd.n69 3.31679
R684 Vdd.n73 Vdd.n72 3.31679
R685 Vdd.n70 Vdd.n68 3.31679
R686 Vdd.n62 Vdd.n59 3.31679
R687 Vdd.n64 Vdd.n62 3.31679
R688 Vdd.n34 Vdd.n31 3.31679
R689 Vdd.n36 Vdd.n33 3.31679
R690 Vdd.n37 Vdd.n36 3.31679
R691 Vdd.n34 Vdd.n32 3.31679
R692 Vdd.n26 Vdd.n23 3.31679
R693 Vdd.n28 Vdd.n26 3.31679
R694 Vdd.n7 Vdd.n5 3.31679
R695 Vdd.n8 Vdd.n7 3.31679
R696 Vdd.n15 Vdd.n14 3.31679
R697 Vdd.n16 Vdd.n15 3.31679
R698 Vdd.n128 Vdd.n127 1.49311
R699 Vdd.n127 Vdd.n126 1.49311
R700 Vdd.n142 Vdd.n118 1.49311
R701 Vdd.n164 Vdd.n163 1.49311
R702 Vdd.n163 Vdd.n162 1.49311
R703 Vdd.n178 Vdd.n154 1.49311
R704 Vdd.n72 Vdd.n71 1.49311
R705 Vdd.n71 Vdd.n70 1.49311
R706 Vdd.n86 Vdd.n62 1.49311
R707 Vdd.n36 Vdd.n35 1.49311
R708 Vdd.n35 Vdd.n34 1.49311
R709 Vdd.n50 Vdd.n26 1.49311
R710 Vdd.n197 Vdd.n196 0.9005
R711 Vdd.n197 Vdd.n188 0.9005
R712 Vdd.n187 Vdd.n184 0.9005
R713 Vdd.n188 Vdd.n187 0.9005
R714 Vdd.n137 Vdd.n119 0.788
R715 Vdd.n119 Vdd.n117 0.788
R716 Vdd.n116 Vdd.n112 0.788
R717 Vdd.n117 Vdd.n116 0.788
R718 Vdd.n173 Vdd.n155 0.788
R719 Vdd.n155 Vdd.n153 0.788
R720 Vdd.n152 Vdd.n148 0.788
R721 Vdd.n153 Vdd.n152 0.788
R722 Vdd.n81 Vdd.n63 0.788
R723 Vdd.n63 Vdd.n61 0.788
R724 Vdd.n60 Vdd.n56 0.788
R725 Vdd.n61 Vdd.n60 0.788
R726 Vdd.n45 Vdd.n27 0.788
R727 Vdd.n27 Vdd.n25 0.788
R728 Vdd.n24 Vdd.n20 0.788
R729 Vdd.n25 Vdd.n24 0.788
R730 Vdd.n91 Vdd.n55 0.6773
R731 Vdd.n204 Vdd.n183 0.6773
R732 Vdd.n183 Vdd.n147 0.6773
R733 Vdd.n100 Vdd.n98 0.6305
R734 Vdd.n106 Vdd.n98 0.6305
R735 Vdd.n107 Vdd.n92 0.6305
R736 Vdd.n107 Vdd.n106 0.6305
R737 Vdd.n13 Vdd.n12 0.6305
R738 Vdd.n13 Vdd.n4 0.6305
R739 Vdd.n3 Vdd.n0 0.6305
R740 Vdd.n4 Vdd.n3 0.6305
R741 Vdd.n111 Vdd.n92 0.600174
R742 Vdd.n19 Vdd.n0 0.600174
R743 Vdd.n146 Vdd.n112 0.496478
R744 Vdd.n182 Vdd.n148 0.496478
R745 Vdd.n90 Vdd.n56 0.496478
R746 Vdd.n54 Vdd.n20 0.496478
R747 Vdd.n203 Vdd.n184 0.454413
R748 Vdd.n205 Vdd.n91 0.4019
R749 Vdd.n205 Vdd.n204 0.1571
R750 Vdd.n103 Vdd.n99 0.1445
R751 Vdd.n109 Vdd.n94 0.1445
R752 Vdd.n110 Vdd.n93 0.1445
R753 Vdd.n102 Vdd.n101 0.1445
R754 Vdd.n135 Vdd.n134 0.1445
R755 Vdd.n134 Vdd.n133 0.1445
R756 Vdd.n133 Vdd.n130 0.1445
R757 Vdd.n140 Vdd.n121 0.1445
R758 Vdd.n121 Vdd.n114 0.1445
R759 Vdd.n144 Vdd.n114 0.1445
R760 Vdd.n139 Vdd.n138 0.1445
R761 Vdd.n138 Vdd.n113 0.1445
R762 Vdd.n145 Vdd.n113 0.1445
R763 Vdd.n136 Vdd.n122 0.1445
R764 Vdd.n132 Vdd.n122 0.1445
R765 Vdd.n132 Vdd.n131 0.1445
R766 Vdd.n171 Vdd.n170 0.1445
R767 Vdd.n170 Vdd.n169 0.1445
R768 Vdd.n169 Vdd.n166 0.1445
R769 Vdd.n176 Vdd.n157 0.1445
R770 Vdd.n157 Vdd.n150 0.1445
R771 Vdd.n180 Vdd.n150 0.1445
R772 Vdd.n175 Vdd.n174 0.1445
R773 Vdd.n174 Vdd.n149 0.1445
R774 Vdd.n181 Vdd.n149 0.1445
R775 Vdd.n172 Vdd.n158 0.1445
R776 Vdd.n168 Vdd.n158 0.1445
R777 Vdd.n168 Vdd.n167 0.1445
R778 Vdd.n194 Vdd.n193 0.1445
R779 Vdd.n201 Vdd.n186 0.1445
R780 Vdd.n202 Vdd.n185 0.1445
R781 Vdd.n195 Vdd.n190 0.1445
R782 Vdd.n79 Vdd.n78 0.1445
R783 Vdd.n78 Vdd.n77 0.1445
R784 Vdd.n77 Vdd.n74 0.1445
R785 Vdd.n84 Vdd.n65 0.1445
R786 Vdd.n65 Vdd.n58 0.1445
R787 Vdd.n88 Vdd.n58 0.1445
R788 Vdd.n83 Vdd.n82 0.1445
R789 Vdd.n82 Vdd.n57 0.1445
R790 Vdd.n89 Vdd.n57 0.1445
R791 Vdd.n80 Vdd.n66 0.1445
R792 Vdd.n76 Vdd.n66 0.1445
R793 Vdd.n76 Vdd.n75 0.1445
R794 Vdd.n43 Vdd.n42 0.1445
R795 Vdd.n42 Vdd.n41 0.1445
R796 Vdd.n41 Vdd.n38 0.1445
R797 Vdd.n48 Vdd.n29 0.1445
R798 Vdd.n29 Vdd.n22 0.1445
R799 Vdd.n52 Vdd.n22 0.1445
R800 Vdd.n47 Vdd.n46 0.1445
R801 Vdd.n46 Vdd.n21 0.1445
R802 Vdd.n53 Vdd.n21 0.1445
R803 Vdd.n44 Vdd.n30 0.1445
R804 Vdd.n40 Vdd.n30 0.1445
R805 Vdd.n40 Vdd.n39 0.1445
R806 Vdd.n10 Vdd.n9 0.1445
R807 Vdd.n17 Vdd.n2 0.1445
R808 Vdd.n18 Vdd.n1 0.1445
R809 Vdd.n11 Vdd.n6 0.1445
C0 Iex_3_i xm9_0/a_28_n131# 0
C1 Iex_4_i xm9_0/a_n50_n339# 0.00459f
C2 xm9_0/a_n50_n339# Vdd 0.94861f
C3 xm4_0/a_28_n281# xm9_0/a_n50_n339# 0.03121f
C4 Iex_4_i xm9_0/a_28_n131# 0
C5 xm9_0/a_28_n131# Vdd 0.5631f
C6 Vin_neg xm9_0/a_n50_n339# 0.00711f
C7 xm4_0/a_28_n281# xm9_0/a_28_n131# 0.43354f
C8 Vin Vdd 0.01025f
C9 Vin_neg xm9_0/a_28_n131# 0.00562f
C10 Iex_2_i Iex_1_i 0.0103f
C11 Iex_4_i Iex_3_i 0.0103f
C12 Iex_3_i Vdd 0.0336f
C13 xm3_0/a_28_n281# Iex_2_i 0.04605f
C14 xm3_0/a_28_n281# Iex_1_i 0.00405f
C15 xm4_0/a_28_n281# Iex_3_i 0.05231f
C16 Vin_neg Iex_3_i 0
C17 Iex_1_i xm9_0/a_n50_n339# 0.00742f
C18 Iex_4_i Vdd 0.03444f
C19 xm3_0/a_28_n281# xm9_0/a_n50_n339# 0.02036f
C20 Iex_4_i xm4_0/a_28_n281# 0.03731f
C21 xm4_0/a_28_n281# Vdd 1.7982f
C22 Iex_1_i xm9_0/a_28_n131# 0
C23 xm3_0/a_28_n281# xm9_0/a_28_n131# 0.03085f
C24 Iex_4_i Vin_neg 0
C25 Vin_neg Vdd 0.00919f
C26 Iex_2_i Vin 0
C27 Vin_neg xm4_0/a_28_n281# 0.00632f
C28 xm3_0/a_28_n281# Vin 0.00522f
C29 xm9_0/a_28_n131# xm9_0/a_n50_n339# 0.23849f
C30 Vin xm9_0/a_n50_n339# 0.00641f
C31 Iex_2_i Vdd 0.03392f
C32 Iex_1_i Vdd 0.04874f
C33 Vin xm9_0/a_28_n131# 0.00163f
C34 xm3_0/a_28_n281# Vdd 1.69087f
C35 Iex_2_i Vss -0.11713f
C36 Iex_1_i Vss -0.12778f
C37 Vdd.n0 Vss 0.01008f
C38 Vdd.n1 Vss 0.00541f
C39 Vdd.n2 Vss 0.0015f
C40 Vdd.n3 Vss 0.00727f
C41 Vdd.n4 Vss 0.06337f
C42 Vdd.n5 Vss 0.00441f
C43 Vdd.n6 Vss 0.00493f
C44 Vdd.n7 Vss 0.04093f
C45 Vdd.n8 Vss 0.00441f
C46 Vdd.n9 Vss 0.0015f
C47 Vdd.n10 Vss 0.0015f
C48 Vdd.n11 Vss 0.00493f
C49 Vdd.n12 Vss 0.02276f
C50 Vdd.n13 Vss 0.00727f
C51 Vdd.n14 Vss 0.00441f
C52 Vdd.n15 Vss 0.04093f
C53 Vdd.n16 Vss 0.00441f
C54 Vdd.n17 Vss 0.0015f
C55 Vdd.n18 Vss 0.00448f
C56 Vdd.n19 Vss 0.01702f
C57 Vdd.n20 Vss 0.0085f
C58 Vdd.n21 Vss 0.00185f
C59 Vdd.n22 Vss 0.00185f
C60 Vdd.n23 Vss 0.00133f
C61 Vdd.n24 Vss 0.00614f
C62 Vdd.n25 Vss 0.06743f
C63 Vdd.n27 Vss 0.00614f
C64 Vdd.n28 Vss 0.00133f
C65 Vdd.n29 Vss 0.00185f
C66 Vdd.n30 Vss 0.00185f
C67 Vdd.n31 Vss 0.00383f
C68 Vdd.n32 Vss 0.00133f
C69 Vdd.n33 Vss 0.00133f
C70 Vdd.n35 Vss 0.04585f
C71 Vdd.n37 Vss 0.00383f
C72 Vdd.n38 Vss 0.0015f
C73 Vdd.n39 Vss 0.00446f
C74 Vdd.n40 Vss 0.00185f
C75 Vdd.n41 Vss 0.00185f
C76 Vdd.n42 Vss 0.00185f
C77 Vdd.n43 Vss 0.0015f
C78 Vdd.n44 Vss 0.00446f
C79 Vdd.n45 Vss 0.01963f
C80 Vdd.n46 Vss 0.00185f
C81 Vdd.n47 Vss 0.00472f
C82 Vdd.n48 Vss 0.0015f
C83 Vdd.n49 Vss 0.00383f
C84 Vdd.n50 Vss 0.04585f
C85 Vdd.n51 Vss 0.00383f
C86 Vdd.n52 Vss 0.0015f
C87 Vdd.n53 Vss 0.00413f
C88 Vdd.n54 Vss 0.01313f
C89 Vdd.n55 Vss 0.07628f
C90 Vdd.n56 Vss 0.0085f
C91 Vdd.n57 Vss 0.00185f
C92 Vdd.n58 Vss 0.00185f
C93 Vdd.n59 Vss 0.00133f
C94 Vdd.n60 Vss 0.00614f
C95 Vdd.n61 Vss 0.06743f
C96 Vdd.n63 Vss 0.00614f
C97 Vdd.n64 Vss 0.00133f
C98 Vdd.n65 Vss 0.00185f
C99 Vdd.n66 Vss 0.00185f
C100 Vdd.n67 Vss 0.00383f
C101 Vdd.n68 Vss 0.00133f
C102 Vdd.n69 Vss 0.00133f
C103 Vdd.n71 Vss 0.04585f
C104 Vdd.n73 Vss 0.00383f
C105 Vdd.n74 Vss 0.0015f
C106 Vdd.n75 Vss 0.00446f
C107 Vdd.n76 Vss 0.00185f
C108 Vdd.n77 Vss 0.00185f
C109 Vdd.n78 Vss 0.00185f
C110 Vdd.n79 Vss 0.0015f
C111 Vdd.n80 Vss 0.00446f
C112 Vdd.n81 Vss 0.01963f
C113 Vdd.n82 Vss 0.00185f
C114 Vdd.n83 Vss 0.00472f
C115 Vdd.n84 Vss 0.0015f
C116 Vdd.n85 Vss 0.00383f
C117 Vdd.n86 Vss 0.04585f
C118 Vdd.n87 Vss 0.00383f
C119 Vdd.n88 Vss 0.0015f
C120 Vdd.n89 Vss 0.00413f
C121 Vdd.n90 Vss 0.01313f
C122 Vdd.n91 Vss 0.0287f
C123 Vdd.n92 Vss 0.01008f
C124 Vdd.n93 Vss 0.00541f
C125 Vdd.n94 Vss 0.0015f
C126 Vdd.n95 Vss 0.04093f
C127 Vdd.n96 Vss 0.00441f
C128 Vdd.n97 Vss 0.00441f
C129 Vdd.n98 Vss 0.00727f
C130 Vdd.n99 Vss 0.0015f
C131 Vdd.n100 Vss 0.02276f
C132 Vdd.n101 Vss 0.00493f
C133 Vdd.n102 Vss 0.00493f
C134 Vdd.n103 Vss 0.0015f
C135 Vdd.n104 Vss 0.00441f
C136 Vdd.n105 Vss 0.04093f
C137 Vdd.n106 Vss 0.06337f
C138 Vdd.n107 Vss 0.00727f
C139 Vdd.n108 Vss 0.00441f
C140 Vdd.n109 Vss 0.0015f
C141 Vdd.n110 Vss 0.00448f
C142 Vdd.n111 Vss 0.01437f
C143 Vdd.n112 Vss 0.0085f
C144 Vdd.n113 Vss 0.00185f
C145 Vdd.n114 Vss 0.00185f
C146 Vdd.n115 Vss 0.00133f
C147 Vdd.n116 Vss 0.00614f
C148 Vdd.n117 Vss 0.06743f
C149 Vdd.n119 Vss 0.00614f
C150 Vdd.n120 Vss 0.00133f
C151 Vdd.n121 Vss 0.00185f
C152 Vdd.n122 Vss 0.00185f
C153 Vdd.n123 Vss 0.00383f
C154 Vdd.n124 Vss 0.00133f
C155 Vdd.n125 Vss 0.00133f
C156 Vdd.n127 Vss 0.04585f
C157 Vdd.n129 Vss 0.00383f
C158 Vdd.n130 Vss 0.0015f
C159 Vdd.n131 Vss 0.00446f
C160 Vdd.n132 Vss 0.00185f
C161 Vdd.n133 Vss 0.00185f
C162 Vdd.n134 Vss 0.00185f
C163 Vdd.n135 Vss 0.0015f
C164 Vdd.n136 Vss 0.00446f
C165 Vdd.n137 Vss 0.01963f
C166 Vdd.n138 Vss 0.00185f
C167 Vdd.n139 Vss 0.00472f
C168 Vdd.n140 Vss 0.0015f
C169 Vdd.n141 Vss 0.00383f
C170 Vdd.n142 Vss 0.04585f
C171 Vdd.n143 Vss 0.00383f
C172 Vdd.n144 Vss 0.0015f
C173 Vdd.n145 Vss 0.00413f
C174 Vdd.n146 Vss 0.01313f
C175 Vdd.n147 Vss 0.05678f
C176 Vdd.n148 Vss 0.0085f
C177 Vdd.n149 Vss 0.00185f
C178 Vdd.n150 Vss 0.00185f
C179 Vdd.n151 Vss 0.00133f
C180 Vdd.n152 Vss 0.00614f
C181 Vdd.n153 Vss 0.06743f
C182 Vdd.n155 Vss 0.00614f
C183 Vdd.n156 Vss 0.00133f
C184 Vdd.n157 Vss 0.00185f
C185 Vdd.n158 Vss 0.00185f
C186 Vdd.n159 Vss 0.00383f
C187 Vdd.n160 Vss 0.00133f
C188 Vdd.n161 Vss 0.00133f
C189 Vdd.n163 Vss 0.04585f
C190 Vdd.n165 Vss 0.00383f
C191 Vdd.n166 Vss 0.0015f
C192 Vdd.n167 Vss 0.00446f
C193 Vdd.n168 Vss 0.00185f
C194 Vdd.n169 Vss 0.00185f
C195 Vdd.n170 Vss 0.00185f
C196 Vdd.n171 Vss 0.0015f
C197 Vdd.n172 Vss 0.00446f
C198 Vdd.n173 Vss 0.01963f
C199 Vdd.n174 Vss 0.00185f
C200 Vdd.n175 Vss 0.00472f
C201 Vdd.n176 Vss 0.0015f
C202 Vdd.n177 Vss 0.00383f
C203 Vdd.n178 Vss 0.04585f
C204 Vdd.n179 Vss 0.00383f
C205 Vdd.n180 Vss 0.0015f
C206 Vdd.n181 Vss 0.00413f
C207 Vdd.n182 Vss 0.01313f
C208 Vdd.n183 Vss 0.03575f
C209 Vdd.n184 Vss 0.00788f
C210 Vdd.n185 Vss 0.00493f
C211 Vdd.n186 Vss 0.0015f
C212 Vdd.n187 Vss 0.00608f
C213 Vdd.n188 Vss 0.04812f
C214 Vdd.n189 Vss 0.00377f
C215 Vdd.n190 Vss 0.00476f
C216 Vdd.n191 Vss 0.0333f
C217 Vdd.n192 Vss 0.00377f
C218 Vdd.n193 Vss 0.0015f
C219 Vdd.n194 Vss 0.0015f
C220 Vdd.n195 Vss 0.00476f
C221 Vdd.n196 Vss 0.01783f
C222 Vdd.n197 Vss 0.00608f
C223 Vdd.n198 Vss 0.00377f
C224 Vdd.n199 Vss 0.0333f
C225 Vdd.n200 Vss 0.00377f
C226 Vdd.n201 Vss 0.0015f
C227 Vdd.n202 Vss 0.00448f
C228 Vdd.n203 Vss 0.01367f
C229 Vdd.n204 Vss 0.02258f
C230 Vdd.n205 Vss 0.0143f
C231 Vss.n0 Vss 0.00737f
C232 Vss.n1 Vss 0.03629f
C233 Vss.n2 Vss 0.00323f
C234 Vss.n3 Vss 0.00195f
C235 Vss.n4 Vss 0
C236 Vss.n5 Vss 0.00155f
C237 Vss.n6 Vss 0.00249f
C238 Vss.n7 Vss 0.02277f
C239 Vss.n8 Vss 0.00155f
C240 Vss.n9 Vss 0.00155f
C241 Vss.n10 Vss 0.00195f
C242 Vss.n11 Vss 0
C243 Vss.n12 Vss 0
C244 Vss.n13 Vss 0.00202f
C245 Vss.n14 Vss 0.00731f
C246 Vss.n15 Vss 0.00249f
C247 Vss.n16 Vss 0.02214f
C248 Vss.n17 Vss 0.03821f
C249 Vss.n18 Vss 0.0187f
C250 Vss.n19 Vss 0.02182f
C251 Vss.n20 Vss 0.00152f
C252 Vss.n21 Vss 0.00152f
C253 Vss.n22 Vss 0.00187f
C254 Vss.n23 Vss 0
C255 Vss.n24 Vss 0
C256 Vss.n25 Vss 0
C257 Vss.n26 Vss 0
C258 Vss.n27 Vss 0
C259 Vss.n28 Vss 0
C260 Vss.n29 Vss 0
C261 Vss.n30 Vss 0
C262 Vss.n31 Vss 0
C263 Vss.n32 Vss 0
C264 Vss.n33 Vss 0
C265 Vss.n34 Vss 0
C266 Vss.n35 Vss 0
C267 Vss.n36 Vss 0
C268 Vss.n37 Vss 0.00176f
C269 Vss.n38 Vss 0
C270 Vss.n39 Vss 0.00243f
C271 Vss.n40 Vss 0.01687f
C272 Vss.n41 Vss 0.03427f
C273 Vss.n42 Vss 0
C274 Vss.n43 Vss 0
C275 Vss.n44 Vss 0
C276 Vss.n45 Vss 0
C277 Vss.n46 Vss 0
C278 Vss.n47 Vss 0.01128f
C279 Vss.n48 Vss 0
C280 Vss.n49 Vss 0
C281 Vss.n50 Vss 0
C282 Vss.n51 Vss 0
C283 Vss.n52 Vss 0
C284 Vss.n53 Vss 0.01687f
C285 Vss.n54 Vss 0
C286 Vss.n55 Vss 0
C287 Vss.n56 Vss 0
C288 Vss.n57 Vss 0
C289 Vss.n58 Vss 0
C290 Vss.n59 Vss 0
C291 Vss.n60 Vss 0
C292 Vss.n61 Vss 0
C293 Vss.n62 Vss 0
C294 Vss.n63 Vss 0.01687f
C295 Vss.n64 Vss 0.01687f
C296 Vss.n65 Vss 0
C297 Vss.n66 Vss 0.01687f
C298 Vss.n67 Vss 0
C299 Vss.n68 Vss 0
C300 Vss.n69 Vss 0
C301 Vss.n70 Vss 0
C302 Vss.n71 Vss 0
C303 Vss.n72 Vss 0
C304 Vss.n73 Vss 0
C305 Vss.n74 Vss 0.01687f
C306 Vss.n75 Vss 0.01687f
C307 Vss.n76 Vss 0
C308 Vss.n77 Vss 0.01402f
C309 Vss.n78 Vss 0
C310 Vss.n79 Vss 0
C311 Vss.n80 Vss 0
C312 Vss.n81 Vss 0
C313 Vss.n82 Vss 0
C314 Vss.n83 Vss 0
C315 Vss.n84 Vss 0
C316 Vss.n85 Vss 0.01687f
C317 Vss.n86 Vss 0.01687f
C318 Vss.n87 Vss 0
C319 Vss.n88 Vss 0.01687f
C320 Vss.n89 Vss 0
C321 Vss.n90 Vss 0
C322 Vss.n91 Vss 0
C323 Vss.n92 Vss 0
C324 Vss.n93 Vss 0.00323f
C325 Vss.n94 Vss 0.00187f
C326 Vss.n95 Vss 0
C327 Vss.n96 Vss 0.00152f
C328 Vss.n97 Vss 0.02182f
C329 Vss.n98 Vss 0.00152f
C330 Vss.n99 Vss 0
C331 Vss.n100 Vss 0
C332 Vss.n101 Vss 0
C333 Vss.n102 Vss 0
C334 Vss.n103 Vss 0
C335 Vss.n104 Vss 0
C336 Vss.n105 Vss 0
C337 Vss.n106 Vss 0
C338 Vss.n107 Vss 0
C339 Vss.n108 Vss 0
C340 Vss.n109 Vss 0
C341 Vss.n110 Vss 0
C342 Vss.n111 Vss 0
C343 Vss.n112 Vss 0
C344 Vss.n113 Vss 0
C345 Vss.n114 Vss 0
C346 Vss.n115 Vss 0
C347 Vss.n116 Vss 0
C348 Vss.n117 Vss 0
C349 Vss.n118 Vss 0
C350 Vss.n119 Vss 0.00187f
C351 Vss.n120 Vss 0.00443f
C352 Vss.n121 Vss 0.00243f
C353 Vss.n122 Vss 0.24326f
C354 Vss.n123 Vss 0.15016f
C355 Vss.n124 Vss 0.07893f
C356 Vss.n125 Vss 0.07893f
C357 Vss.n126 Vss 0.02277f
C358 Vss.n127 Vss 0.00155f
C359 Vss.n128 Vss 0.00155f
C360 Vss.n129 Vss 0.00202f
C361 Vss.n130 Vss 0.00184f
C362 Vss.n131 Vss 0.00249f
C363 Vss.n132 Vss 0
C364 Vss.n133 Vss 0.00377f
C365 Vss.n134 Vss 0.00323f
C366 Vss.n135 Vss 0.00195f
C367 Vss.n136 Vss 0
C368 Vss.n137 Vss 0.00155f
C369 Vss.n138 Vss 0.02366f
C370 Vss.n139 Vss 0.00152f
C371 Vss.n140 Vss 0.00152f
C372 Vss.n141 Vss 0.00187f
C373 Vss.n142 Vss 0
C374 Vss.n143 Vss 0
C375 Vss.n144 Vss 0
C376 Vss.n145 Vss 0
C377 Vss.n146 Vss 0
C378 Vss.n147 Vss 0.01613f
C379 Vss.n148 Vss 0.01687f
C380 Vss.n149 Vss 0.01687f
C381 Vss.n150 Vss 0
C382 Vss.n151 Vss 0
C383 Vss.n152 Vss 0
C384 Vss.n153 Vss 0
C385 Vss.n154 Vss 0
C386 Vss.n155 Vss 0
C387 Vss.n156 Vss 0
C388 Vss.n157 Vss 0
C389 Vss.n158 Vss 0
C390 Vss.n159 Vss 0
C391 Vss.n160 Vss 0
C392 Vss.n161 Vss 0
C393 Vss.n162 Vss 0
C394 Vss.n163 Vss 0.01687f
C395 Vss.n164 Vss 0
C396 Vss.n165 Vss 0
C397 Vss.n166 Vss 0
C398 Vss.n167 Vss 0
C399 Vss.n168 Vss 0
C400 Vss.n169 Vss 0
C401 Vss.n170 Vss 0
C402 Vss.n171 Vss 0
C403 Vss.n172 Vss 0.082f
C404 Vss.n173 Vss 0.10518f
C405 Vss.n174 Vss 0
C406 Vss.n175 Vss 0
C407 Vss.n176 Vss 0.01687f
C408 Vss.n177 Vss 0
C409 Vss.n178 Vss 0
C410 Vss.n179 Vss 0
C411 Vss.n180 Vss 0
C412 Vss.n181 Vss 0
C413 Vss.n182 Vss 0
C414 Vss.n183 Vss 0.00152f
C415 Vss.n184 Vss 0
C416 Vss.n185 Vss 0.00152f
C417 Vss.n186 Vss 0.00187f
C418 Vss.n187 Vss 0
C419 Vss.n188 Vss 0
C420 Vss.n189 Vss 0
C421 Vss.n190 Vss 0
C422 Vss.n191 Vss 0
C423 Vss.n192 Vss 0
C424 Vss.n193 Vss 0
C425 Vss.n194 Vss 0
C426 Vss.n195 Vss 0
C427 Vss.n196 Vss 0
C428 Vss.n197 Vss 0
C429 Vss.n198 Vss 0
C430 Vss.n199 Vss 0
C431 Vss.n200 Vss 0
C432 Vss.n201 Vss 0
C433 Vss.n202 Vss 0
C434 Vss.n203 Vss 0
C435 Vss.n204 Vss 0
C436 Vss.n205 Vss 0
C437 Vss.n206 Vss 0
C438 Vss.n207 Vss 0
C439 Vss.n208 Vss 0
C440 Vss.n209 Vss 0.00176f
C441 Vss.n210 Vss 0.00804f
C442 Vss.n211 Vss 0.00323f
C443 Vss.n212 Vss 0.00243f
C444 Vss.n213 Vss 0.09053f
C445 Vss.n214 Vss 0.02182f
C446 Vss.n215 Vss 0.01687f
C447 Vss.n216 Vss 0
C448 Vss.n217 Vss 0
C449 Vss.n218 Vss 0
C450 Vss.n219 Vss 0
C451 Vss.n220 Vss 0
C452 Vss.n221 Vss 0.01687f
C453 Vss.n222 Vss 0.01276f
C454 Vss.n223 Vss 0.0187f
C455 Vss.n224 Vss 0.01255f
C456 Vss.n225 Vss 0
C457 Vss.n226 Vss 0
C458 Vss.n227 Vss 0
C459 Vss.n228 Vss 0
C460 Vss.n229 Vss 0
C461 Vss.n230 Vss 0.01687f
C462 Vss.n231 Vss 0.01687f
C463 Vss.n232 Vss 0.01687f
C464 Vss.n233 Vss 0
C465 Vss.n234 Vss 0
C466 Vss.n235 Vss 0
C467 Vss.n236 Vss 0
C468 Vss.n237 Vss 0
C469 Vss.n238 Vss 0.01687f
C470 Vss.n239 Vss 0
C471 Vss.n240 Vss 0
C472 Vss.n241 Vss 0
C473 Vss.n242 Vss 0
C474 Vss.n243 Vss 0.00187f
C475 Vss.n244 Vss 0.00443f
C476 Vss.n245 Vss 0.00243f
C477 Vss.n246 Vss 0.03437f
C478 Vss.n247 Vss 0.04302f
C479 Vss.n248 Vss 0.02277f
C480 Vss.n249 Vss 0.00155f
C481 Vss.n250 Vss 0
C482 Vss.n251 Vss 0
C483 Vss.n252 Vss 0.00195f
C484 Vss.n253 Vss 0.00731f
C485 Vss.n254 Vss 0.00249f
C486 Vss.n255 Vss 0.02214f
C487 Vss.n256 Vss 0.03821f
C488 Vss.n257 Vss 0.03521f
C489 Vss.n258 Vss 0.02277f
C490 Vss.n259 Vss 0.00155f
C491 Vss.n260 Vss 0
C492 Vss.n261 Vss 0.00184f
C493 Vss.n262 Vss 0.00377f
C494 Vss.n263 Vss 0.00714f
C495 Vss.n264 Vss 0.04587f
C496 Vin.n0 Vss 0.02364f
C497 Vin_neg.n0 Vss 0.02892f
C498 Iex_4_i Vss -0.11568f
C499 Vin_neg Vss -0.16352f
C500 xm4_0/a_28_n281# Vss -1.97907f
C501 Iex_3_i Vss -0.11211f
C502 Vin Vss -0.15344f
C503 xm9_0/a_28_n131# Vss -0.4305f
C504 Vdd Vss -13.49906f
C505 xm9_0/a_n50_n339# Vss -0.79751f
C506 xm3_0/a_28_n281# Vss -1.41866f
R341 Vss.n15 Vss.n14 0.743357
R342 Vss.n16 Vss.n15 0.743357
R343 Vss.n6 Vss.n2 0.743357
R344 Vss.n257 Vss.n6 0.743357
R345 Vss.n254 Vss.n253 0.743357
R346 Vss.n255 Vss.n254 0.743357
R347 Vss.n134 Vss.n131 0.743357
R348 Vss.n247 Vss.n131 0.743357
R349 Vss.n245 Vss.n244 0.743357
R350 Vss.n246 Vss.n245 0.743357
R351 Vss.n212 Vss.n211 0.743357
R352 Vss.n213 Vss.n212 0.743357
R353 Vss.n121 Vss.n120 0.743357
R354 Vss.n122 Vss.n121 0.743357
R355 Vss.n93 Vss.n39 0.743357
R356 Vss.n41 Vss.n39 0.743357
R357 Vss.n263 Vss.n1 0.5621
R358 Vss.n211 Vss.n210 0.454413
R359 Vss.n134 Vss.n133 0.454413
R360 Vss.n262 Vss.n2 0.454413
R361 Vss.n93 Vss.n0 0.454413
R362 Vss.n242 Vss.n241 0.1445
R363 Vss.n241 Vss.n240 0.1445
R364 Vss.n240 Vss.n145 0.1445
R365 Vss.n193 Vss.n145 0.1445
R366 Vss.n194 Vss.n193 0.1445
R367 Vss.n194 Vss.n190 0.1445
R368 Vss.n199 Vss.n190 0.1445
R369 Vss.n200 Vss.n199 0.1445
R370 Vss.n201 Vss.n200 0.1445
R371 Vss.n201 Vss.n188 0.1445
R372 Vss.n206 Vss.n188 0.1445
R373 Vss.n207 Vss.n206 0.1445
R374 Vss.n208 Vss.n207 0.1445
R375 Vss.n153 Vss.n152 0.1445
R376 Vss.n236 Vss.n153 0.1445
R377 Vss.n236 Vss.n235 0.1445
R378 Vss.n235 Vss.n234 0.1445
R379 Vss.n234 Vss.n158 0.1445
R380 Vss.n228 Vss.n158 0.1445
R381 Vss.n228 Vss.n227 0.1445
R382 Vss.n227 Vss.n226 0.1445
R383 Vss.n226 Vss.n169 0.1445
R384 Vss.n219 Vss.n169 0.1445
R385 Vss.n219 Vss.n218 0.1445
R386 Vss.n218 Vss.n217 0.1445
R387 Vss.n217 Vss.n182 0.1445
R388 Vss.n154 Vss.n141 0.1445
R389 Vss.n155 Vss.n154 0.1445
R390 Vss.n156 Vss.n155 0.1445
R391 Vss.n157 Vss.n156 0.1445
R392 Vss.n165 Vss.n157 0.1445
R393 Vss.n166 Vss.n165 0.1445
R394 Vss.n167 Vss.n166 0.1445
R395 Vss.n168 Vss.n167 0.1445
R396 Vss.n178 Vss.n168 0.1445
R397 Vss.n179 Vss.n178 0.1445
R398 Vss.n180 Vss.n179 0.1445
R399 Vss.n181 Vss.n180 0.1445
R400 Vss.n186 Vss.n181 0.1445
R401 Vss.n243 Vss.n142 0.1445
R402 Vss.n144 Vss.n142 0.1445
R403 Vss.n191 Vss.n144 0.1445
R404 Vss.n192 Vss.n191 0.1445
R405 Vss.n195 Vss.n192 0.1445
R406 Vss.n196 Vss.n195 0.1445
R407 Vss.n197 Vss.n196 0.1445
R408 Vss.n197 Vss.n189 0.1445
R409 Vss.n202 Vss.n189 0.1445
R410 Vss.n203 Vss.n202 0.1445
R411 Vss.n204 Vss.n203 0.1445
R412 Vss.n204 Vss.n187 0.1445
R413 Vss.n209 Vss.n187 0.1445
R414 Vss.n251 Vss.n250 0.1445
R415 Vss.n252 Vss.n130 0.1445
R416 Vss.n135 Vss.n129 0.1445
R417 Vss.n136 Vss.n132 0.1445
R418 Vss.n260 Vss.n4 0.1445
R419 Vss.n261 Vss.n3 0.1445
R420 Vss.n13 Vss.n10 0.1445
R421 Vss.n12 Vss.n11 0.1445
R422 Vss.n61 Vss.n59 0.1445
R423 Vss.n61 Vss.n57 0.1445
R424 Vss.n68 Vss.n57 0.1445
R425 Vss.n68 Vss.n55 0.1445
R426 Vss.n72 Vss.n55 0.1445
R427 Vss.n72 Vss.n51 0.1445
R428 Vss.n79 Vss.n51 0.1445
R429 Vss.n79 Vss.n49 0.1445
R430 Vss.n83 Vss.n49 0.1445
R431 Vss.n83 Vss.n45 0.1445
R432 Vss.n90 Vss.n45 0.1445
R433 Vss.n90 Vss.n43 0.1445
R434 Vss.n95 Vss.n43 0.1445
R435 Vss.n118 Vss.n117 0.1445
R436 Vss.n117 Vss.n116 0.1445
R437 Vss.n116 Vss.n26 0.1445
R438 Vss.n112 Vss.n26 0.1445
R439 Vss.n112 Vss.n111 0.1445
R440 Vss.n111 Vss.n110 0.1445
R441 Vss.n110 Vss.n31 0.1445
R442 Vss.n106 Vss.n31 0.1445
R443 Vss.n106 Vss.n105 0.1445
R444 Vss.n105 Vss.n104 0.1445
R445 Vss.n104 Vss.n36 0.1445
R446 Vss.n100 Vss.n36 0.1445
R447 Vss.n100 Vss.n99 0.1445
R448 Vss.n119 Vss.n23 0.1445
R449 Vss.n115 Vss.n23 0.1445
R450 Vss.n115 Vss.n114 0.1445
R451 Vss.n114 Vss.n113 0.1445
R452 Vss.n113 Vss.n27 0.1445
R453 Vss.n109 Vss.n27 0.1445
R454 Vss.n109 Vss.n108 0.1445
R455 Vss.n108 Vss.n107 0.1445
R456 Vss.n107 Vss.n32 0.1445
R457 Vss.n103 Vss.n32 0.1445
R458 Vss.n103 Vss.n102 0.1445
R459 Vss.n102 Vss.n101 0.1445
R460 Vss.n101 Vss.n37 0.1445
R461 Vss.n60 Vss.n22 0.1445
R462 Vss.n60 Vss.n56 0.1445
R463 Vss.n69 Vss.n56 0.1445
R464 Vss.n70 Vss.n69 0.1445
R465 Vss.n71 Vss.n70 0.1445
R466 Vss.n71 Vss.n50 0.1445
R467 Vss.n80 Vss.n50 0.1445
R468 Vss.n81 Vss.n80 0.1445
R469 Vss.n82 Vss.n81 0.1445
R470 Vss.n82 Vss.n44 0.1445
R471 Vss.n91 Vss.n44 0.1445
R472 Vss.n92 Vss.n91 0.1445
R473 Vss.n94 Vss.n92 0.1445
R474 Vss Vss.n263 0.1013
R475 Vdd.n106 Vdd.n95 696.312
R476 Vdd.n106 Vdd.n105 696.312
R477 Vdd.n15 Vdd.n4 696.312
R478 Vdd.n7 Vdd.n4 696.312
R479 Vdd.n199 Vdd.n188 528.52
R480 Vdd.n191 Vdd.n188 528.52
R481 Vdd.n142 Vdd.n117 446.678
R482 Vdd.n127 Vdd.n117 446.678
R483 Vdd.n178 Vdd.n153 446.678
R484 Vdd.n163 Vdd.n153 446.678
R485 Vdd.n86 Vdd.n61 446.678
R486 Vdd.n71 Vdd.n61 446.678
R487 Vdd.n50 Vdd.n25 446.678
R488 Vdd.n35 Vdd.n25 446.678
R489 Vdd.n108 Vdd.n107 74.638
R490 Vdd.n107 Vdd.n96 74.638
R491 Vdd.n104 Vdd.n98 74.638
R492 Vdd.n98 Vdd.n97 74.638
R493 Vdd.n16 Vdd.n3 74.638
R494 Vdd.n8 Vdd.n3 74.638
R495 Vdd.n13 Vdd.n5 74.638
R496 Vdd.n14 Vdd.n13 74.638
R497 Vdd.n143 Vdd.n116 62.563
R498 Vdd.n129 Vdd.n116 62.563
R499 Vdd.n123 Vdd.n119 62.563
R500 Vdd.n141 Vdd.n119 62.563
R501 Vdd.n179 Vdd.n152 62.563
R502 Vdd.n165 Vdd.n152 62.563
R503 Vdd.n159 Vdd.n155 62.563
R504 Vdd.n177 Vdd.n155 62.563
R505 Vdd.n87 Vdd.n60 62.563
R506 Vdd.n73 Vdd.n60 62.563
R507 Vdd.n67 Vdd.n63 62.563
R508 Vdd.n85 Vdd.n63 62.563
R509 Vdd.n51 Vdd.n24 62.563
R510 Vdd.n37 Vdd.n24 62.563
R511 Vdd.n31 Vdd.n27 62.563
R512 Vdd.n49 Vdd.n27 62.563
R513 Vdd.n200 Vdd.n187 61.6005
R514 Vdd.n192 Vdd.n187 61.6005
R515 Vdd.n197 Vdd.n189 61.6005
R516 Vdd.n198 Vdd.n197 61.6005
R517 Vdd.n125 Vdd.n124 14.0005
R518 Vdd.n141 Vdd.n120 14.0005
R519 Vdd.n143 Vdd.n115 14.0005
R520 Vdd.n161 Vdd.n160 14.0005
R521 Vdd.n177 Vdd.n156 14.0005
R522 Vdd.n179 Vdd.n151 14.0005
R523 Vdd.n69 Vdd.n68 14.0005
R524 Vdd.n85 Vdd.n64 14.0005
R525 Vdd.n87 Vdd.n59 14.0005
R526 Vdd.n33 Vdd.n32 14.0005
R527 Vdd.n49 Vdd.n28 14.0005
R528 Vdd.n51 Vdd.n23 14.0005
R529 Vdd.n99 Vdd.n96 6.3005
R530 Vdd.n104 Vdd.n103 6.3005
R531 Vdd.n97 Vdd.n94 6.3005
R532 Vdd.n109 Vdd.n108 6.3005
R533 Vdd.n130 Vdd.n129 6.3005
R534 Vdd.n133 Vdd.n125 6.3005
R535 Vdd.n134 Vdd.n124 6.3005
R536 Vdd.n135 Vdd.n123 6.3005
R537 Vdd.n144 Vdd.n143 6.3005
R538 Vdd.n143 Vdd.n142 6.3005
R539 Vdd.n115 Vdd.n114 6.3005
R540 Vdd.n121 Vdd.n120 6.3005
R541 Vdd.n141 Vdd.n140 6.3005
R542 Vdd.n142 Vdd.n141 6.3005
R543 Vdd.n166 Vdd.n165 6.3005
R544 Vdd.n169 Vdd.n161 6.3005
R545 Vdd.n170 Vdd.n160 6.3005
R546 Vdd.n171 Vdd.n159 6.3005
R547 Vdd.n180 Vdd.n179 6.3005
R548 Vdd.n179 Vdd.n178 6.3005
R549 Vdd.n151 Vdd.n150 6.3005
R550 Vdd.n157 Vdd.n156 6.3005
R551 Vdd.n177 Vdd.n176 6.3005
R552 Vdd.n178 Vdd.n177 6.3005
R553 Vdd.n193 Vdd.n192 6.3005
R554 Vdd.n194 Vdd.n189 6.3005
R555 Vdd.n201 Vdd.n200 6.3005
R556 Vdd.n198 Vdd.n186 6.3005
R557 Vdd.n74 Vdd.n73 6.3005
R558 Vdd.n77 Vdd.n69 6.3005
R559 Vdd.n78 Vdd.n68 6.3005
R560 Vdd.n79 Vdd.n67 6.3005
R561 Vdd.n88 Vdd.n87 6.3005
R562 Vdd.n87 Vdd.n86 6.3005
R563 Vdd.n59 Vdd.n58 6.3005
R564 Vdd.n65 Vdd.n64 6.3005
R565 Vdd.n85 Vdd.n84 6.3005
R566 Vdd.n86 Vdd.n85 6.3005
R567 Vdd.n38 Vdd.n37 6.3005
R568 Vdd.n41 Vdd.n33 6.3005
R569 Vdd.n42 Vdd.n32 6.3005
R570 Vdd.n43 Vdd.n31 6.3005
R571 Vdd.n52 Vdd.n51 6.3005
R572 Vdd.n51 Vdd.n50 6.3005
R573 Vdd.n23 Vdd.n22 6.3005
R574 Vdd.n29 Vdd.n28 6.3005
R575 Vdd.n49 Vdd.n48 6.3005
R576 Vdd.n50 Vdd.n49 6.3005
R577 Vdd.n9 Vdd.n8 6.3005
R578 Vdd.n10 Vdd.n5 6.3005
R579 Vdd.n17 Vdd.n16 6.3005
R580 Vdd.n14 Vdd.n2 6.3005
R581 Vdd.n55 Vdd.n19 5.89534
R582 Vdd.n147 Vdd.n111 5.78014
R583 Vdd.n204 Vdd.n203 5.51007
R584 Vdd.n147 Vdd.n146 5.42593
R585 Vdd.n183 Vdd.n182 5.42593
R586 Vdd.n91 Vdd.n90 5.42593
R587 Vdd.n55 Vdd.n54 5.42593
R588 Vdd.n102 Vdd.n100 5.34137
R589 Vdd.n101 Vdd.n92 5.34137
R590 Vdd.n12 Vdd.n11 5.34137
R591 Vdd.n6 Vdd.n0 5.34137
R592 Vdd.n100 Vdd.n93 5.33355
R593 Vdd.n12 Vdd.n1 5.33355
R594 Vdd.n137 Vdd.n136 5.20888
R595 Vdd.n131 Vdd.n112 5.20888
R596 Vdd.n173 Vdd.n172 5.20888
R597 Vdd.n167 Vdd.n148 5.20888
R598 Vdd.n81 Vdd.n80 5.20888
R599 Vdd.n75 Vdd.n56 5.20888
R600 Vdd.n45 Vdd.n44 5.20888
R601 Vdd.n39 Vdd.n20 5.20888
R602 Vdd.n139 Vdd.n137 5.20105
R603 Vdd.n175 Vdd.n173 5.20105
R604 Vdd.n83 Vdd.n81 5.20105
R605 Vdd.n47 Vdd.n45 5.20105
R606 Vdd.n196 Vdd.n195 5.19561
R607 Vdd.n190 Vdd.n184 5.19561
R608 Vdd.n196 Vdd.n185 5.18779
R609 Vdd.n111 Vdd.n110 4.7417
R610 Vdd.n203 Vdd.n202 4.7417
R611 Vdd.n19 Vdd.n18 4.7417
R612 Vdd.n146 Vdd.n145 4.7129
R613 Vdd.n182 Vdd.n181 4.7129
R614 Vdd.n90 Vdd.n89 4.7129
R615 Vdd.n54 Vdd.n53 4.7129
R616 Vdd.n94 Vdd.n93 4.5005
R617 Vdd.n110 Vdd.n109 4.5005
R618 Vdd.n101 Vdd.n99 4.5005
R619 Vdd.n103 Vdd.n102 4.5005
R620 Vdd.n138 Vdd.n121 4.5005
R621 Vdd.n114 Vdd.n113 4.5005
R622 Vdd.n145 Vdd.n144 4.5005
R623 Vdd.n140 Vdd.n139 4.5005
R624 Vdd.n134 Vdd.n122 4.5005
R625 Vdd.n133 Vdd.n132 4.5005
R626 Vdd.n131 Vdd.n130 4.5005
R627 Vdd.n136 Vdd.n135 4.5005
R628 Vdd.n174 Vdd.n157 4.5005
R629 Vdd.n150 Vdd.n149 4.5005
R630 Vdd.n181 Vdd.n180 4.5005
R631 Vdd.n176 Vdd.n175 4.5005
R632 Vdd.n170 Vdd.n158 4.5005
R633 Vdd.n169 Vdd.n168 4.5005
R634 Vdd.n167 Vdd.n166 4.5005
R635 Vdd.n172 Vdd.n171 4.5005
R636 Vdd.n202 Vdd.n201 4.5005
R637 Vdd.n186 Vdd.n185 4.5005
R638 Vdd.n193 Vdd.n190 4.5005
R639 Vdd.n195 Vdd.n194 4.5005
R640 Vdd.n82 Vdd.n65 4.5005
R641 Vdd.n58 Vdd.n57 4.5005
R642 Vdd.n89 Vdd.n88 4.5005
R643 Vdd.n84 Vdd.n83 4.5005
R644 Vdd.n78 Vdd.n66 4.5005
R645 Vdd.n77 Vdd.n76 4.5005
R646 Vdd.n75 Vdd.n74 4.5005
R647 Vdd.n80 Vdd.n79 4.5005
R648 Vdd.n46 Vdd.n29 4.5005
R649 Vdd.n22 Vdd.n21 4.5005
R650 Vdd.n53 Vdd.n52 4.5005
R651 Vdd.n48 Vdd.n47 4.5005
R652 Vdd.n42 Vdd.n30 4.5005
R653 Vdd.n41 Vdd.n40 4.5005
R654 Vdd.n39 Vdd.n38 4.5005
R655 Vdd.n44 Vdd.n43 4.5005
R656 Vdd.n18 Vdd.n17 4.5005
R657 Vdd.n2 Vdd.n1 4.5005
R658 Vdd.n9 Vdd.n6 4.5005
R659 Vdd.n11 Vdd.n10 4.5005
R660 Vdd.n105 Vdd.n104 3.31679
R661 Vdd.n105 Vdd.n96 3.31679
R662 Vdd.n108 Vdd.n95 3.31679
R663 Vdd.n97 Vdd.n95 3.31679
R664 Vdd.n126 Vdd.n123 3.31679
R665 Vdd.n128 Vdd.n125 3.31679
R666 Vdd.n129 Vdd.n128 3.31679
R667 Vdd.n126 Vdd.n124 3.31679
R668 Vdd.n118 Vdd.n115 3.31679
R669 Vdd.n120 Vdd.n118 3.31679
R670 Vdd.n162 Vdd.n159 3.31679
R671 Vdd.n164 Vdd.n161 3.31679
R672 Vdd.n165 Vdd.n164 3.31679
R673 Vdd.n162 Vdd.n160 3.31679
R674 Vdd.n154 Vdd.n151 3.31679
R675 Vdd.n156 Vdd.n154 3.31679
R676 Vdd.n191 Vdd.n189 3.31679
R677 Vdd.n192 Vdd.n191 3.31679
R678 Vdd.n199 Vdd.n198 3.31679
R679 Vdd.n200 Vdd.n199 3.31679
R680 Vdd.n70 Vdd.n67 3.31679
R681 Vdd.n72 Vdd.n69 3.31679
R682 Vdd.n73 Vdd.n72 3.31679
R683 Vdd.n70 Vdd.n68 3.31679
R684 Vdd.n62 Vdd.n59 3.31679
R685 Vdd.n64 Vdd.n62 3.31679
R686 Vdd.n34 Vdd.n31 3.31679
R687 Vdd.n36 Vdd.n33 3.31679
R688 Vdd.n37 Vdd.n36 3.31679
R689 Vdd.n34 Vdd.n32 3.31679
R690 Vdd.n26 Vdd.n23 3.31679
R691 Vdd.n28 Vdd.n26 3.31679
R692 Vdd.n7 Vdd.n5 3.31679
R693 Vdd.n8 Vdd.n7 3.31679
R694 Vdd.n15 Vdd.n14 3.31679
R695 Vdd.n16 Vdd.n15 3.31679
R696 Vdd.n128 Vdd.n127 1.49311
R697 Vdd.n127 Vdd.n126 1.49311
R698 Vdd.n142 Vdd.n118 1.49311
R699 Vdd.n164 Vdd.n163 1.49311
R700 Vdd.n163 Vdd.n162 1.49311
R701 Vdd.n178 Vdd.n154 1.49311
R702 Vdd.n72 Vdd.n71 1.49311
R703 Vdd.n71 Vdd.n70 1.49311
R704 Vdd.n86 Vdd.n62 1.49311
R705 Vdd.n36 Vdd.n35 1.49311
R706 Vdd.n35 Vdd.n34 1.49311
R707 Vdd.n50 Vdd.n26 1.49311
R708 Vdd.n197 Vdd.n196 0.9005
R709 Vdd.n197 Vdd.n188 0.9005
R710 Vdd.n187 Vdd.n184 0.9005
R711 Vdd.n188 Vdd.n187 0.9005
R712 Vdd.n137 Vdd.n119 0.788
R713 Vdd.n119 Vdd.n117 0.788
R714 Vdd.n116 Vdd.n112 0.788
R715 Vdd.n117 Vdd.n116 0.788
R716 Vdd.n173 Vdd.n155 0.788
R717 Vdd.n155 Vdd.n153 0.788
R718 Vdd.n152 Vdd.n148 0.788
R719 Vdd.n153 Vdd.n152 0.788
R720 Vdd.n81 Vdd.n63 0.788
R721 Vdd.n63 Vdd.n61 0.788
R722 Vdd.n60 Vdd.n56 0.788
R723 Vdd.n61 Vdd.n60 0.788
R724 Vdd.n45 Vdd.n27 0.788
R725 Vdd.n27 Vdd.n25 0.788
R726 Vdd.n24 Vdd.n20 0.788
R727 Vdd.n25 Vdd.n24 0.788
R728 Vdd.n91 Vdd.n55 0.6773
R729 Vdd.n204 Vdd.n183 0.6773
R730 Vdd.n183 Vdd.n147 0.6773
R731 Vdd.n100 Vdd.n98 0.6305
R732 Vdd.n106 Vdd.n98 0.6305
R733 Vdd.n107 Vdd.n92 0.6305
R734 Vdd.n107 Vdd.n106 0.6305
R735 Vdd.n13 Vdd.n12 0.6305
R736 Vdd.n13 Vdd.n4 0.6305
R737 Vdd.n3 Vdd.n0 0.6305
R738 Vdd.n4 Vdd.n3 0.6305
R739 Vdd.n111 Vdd.n92 0.600174
R740 Vdd.n19 Vdd.n0 0.600174
R741 Vdd.n146 Vdd.n112 0.496478
R742 Vdd.n182 Vdd.n148 0.496478
R743 Vdd.n90 Vdd.n56 0.496478
R744 Vdd.n54 Vdd.n20 0.496478
R745 Vdd.n203 Vdd.n184 0.454413
R746 Vdd Vdd.n91 0.4019
R747 Vdd Vdd.n204 0.1571
R748 Vdd.n103 Vdd.n99 0.1445
R749 Vdd.n109 Vdd.n94 0.1445
R750 Vdd.n110 Vdd.n93 0.1445
R751 Vdd.n102 Vdd.n101 0.1445
R752 Vdd.n135 Vdd.n134 0.1445
R753 Vdd.n134 Vdd.n133 0.1445
R754 Vdd.n133 Vdd.n130 0.1445
R755 Vdd.n140 Vdd.n121 0.1445
R756 Vdd.n121 Vdd.n114 0.1445
R757 Vdd.n144 Vdd.n114 0.1445
R758 Vdd.n139 Vdd.n138 0.1445
R759 Vdd.n138 Vdd.n113 0.1445
R760 Vdd.n145 Vdd.n113 0.1445
R761 Vdd.n136 Vdd.n122 0.1445
R762 Vdd.n132 Vdd.n122 0.1445
R763 Vdd.n132 Vdd.n131 0.1445
R764 Vdd.n171 Vdd.n170 0.1445
R765 Vdd.n170 Vdd.n169 0.1445
R766 Vdd.n169 Vdd.n166 0.1445
R767 Vdd.n176 Vdd.n157 0.1445
R768 Vdd.n157 Vdd.n150 0.1445
R769 Vdd.n180 Vdd.n150 0.1445
R770 Vdd.n175 Vdd.n174 0.1445
R771 Vdd.n174 Vdd.n149 0.1445
R772 Vdd.n181 Vdd.n149 0.1445
R773 Vdd.n172 Vdd.n158 0.1445
R774 Vdd.n168 Vdd.n158 0.1445
R775 Vdd.n168 Vdd.n167 0.1445
R776 Vdd.n194 Vdd.n193 0.1445
R777 Vdd.n201 Vdd.n186 0.1445
R778 Vdd.n202 Vdd.n185 0.1445
R779 Vdd.n195 Vdd.n190 0.1445
R780 Vdd.n79 Vdd.n78 0.1445
R781 Vdd.n78 Vdd.n77 0.1445
R782 Vdd.n77 Vdd.n74 0.1445
R783 Vdd.n84 Vdd.n65 0.1445
R784 Vdd.n65 Vdd.n58 0.1445
R785 Vdd.n88 Vdd.n58 0.1445
R786 Vdd.n83 Vdd.n82 0.1445
R787 Vdd.n82 Vdd.n57 0.1445
R788 Vdd.n89 Vdd.n57 0.1445
R789 Vdd.n80 Vdd.n66 0.1445
R790 Vdd.n76 Vdd.n66 0.1445
R791 Vdd.n76 Vdd.n75 0.1445
R792 Vdd.n43 Vdd.n42 0.1445
R793 Vdd.n42 Vdd.n41 0.1445
R794 Vdd.n41 Vdd.n38 0.1445
R795 Vdd.n48 Vdd.n29 0.1445
R796 Vdd.n29 Vdd.n22 0.1445
R797 Vdd.n52 Vdd.n22 0.1445
R798 Vdd.n47 Vdd.n46 0.1445
R799 Vdd.n46 Vdd.n21 0.1445
R800 Vdd.n53 Vdd.n21 0.1445
R801 Vdd.n44 Vdd.n30 0.1445
R802 Vdd.n40 Vdd.n30 0.1445
R803 Vdd.n40 Vdd.n39 0.1445
R804 Vdd.n10 Vdd.n9 0.1445
R805 Vdd.n17 Vdd.n2 0.1445
R806 Vdd.n18 Vdd.n1 0.1445
R807 Vdd.n11 Vdd.n6 0.1445
C0 xm9_0/a_n50_n339# Iex_4_i 0.00357f
C1 xm3_0/a_28_n281# Vdd 1.69168f
C2 Vdd xm9_0/a_n50_n339# 0.95653f
C3 xm9_0/a_28_n131# Iex_3_i 0.00408f
C4 xm9_0/a_n50_n339# Vin_neg 0.00655f
C5 Vdd Iex_4_i 0.00908f
C6 Iex_2_i Vin 0
C7 xm9_0/a_28_n131# Iex_1_i 0.00408f
C8 xm9_0/a_n50_n339# xm4_0/a_28_n281# 0.03121f
C9 Iex_2_i xm3_0/a_28_n281# 0.03622f
C10 Iex_4_i Vin_neg 0
C11 Vdd Vin_neg 0.00868f
C12 Iex_4_i xm4_0/a_28_n281# 0.03326f
C13 Vdd xm4_0/a_28_n281# 1.80055f
C14 Iex_2_i Vdd 0.01027f
C15 xm4_0/a_28_n281# Vin_neg 0.00538f
C16 xm9_0/a_28_n131# Vin 0.00116f
C17 xm3_0/a_28_n281# xm9_0/a_28_n131# 0.04461f
C18 xm9_0/a_28_n131# xm9_0/a_n50_n339# 0.20766f
C19 xm9_0/a_28_n131# Iex_4_i 0.00408f
C20 xm9_0/a_28_n131# Vdd 0.31488f
C21 xm9_0/a_28_n131# Vin_neg 0.0425f
C22 Iex_1_i xm9_0/a_n50_n339# 0.00645f
C23 xm9_0/a_28_n131# xm4_0/a_28_n281# 0.42403f
C24 Iex_4_i Iex_3_i 0.00482f
C25 Vdd Iex_3_i 0.01046f
C26 Iex_3_i Vin_neg 0
C27 Vdd Iex_1_i 0.02308f
C28 xm3_0/a_28_n281# Vin 0.00428f
C29 xm4_0/a_28_n281# Iex_3_i 0.04082f
C30 xm9_0/a_n50_n339# Vin 0.00641f
C31 xm3_0/a_28_n281# xm9_0/a_n50_n339# 0.02036f
C32 Iex_2_i Iex_1_i 0.00482f
C33 Vdd Vin 0.00973f
C34 Vdd.n0 Vss 0.00994f
C35 Vdd.n1 Vss 0.00533f
C36 Vdd.n2 Vss 0.00148f
C37 Vdd.n3 Vss 0.00717f
C38 Vdd.n4 Vss 0.06245f
C39 Vdd.n5 Vss 0.00435f
C40 Vdd.n6 Vss 0.00486f
C41 Vdd.n7 Vss 0.04034f
C42 Vdd.n8 Vss 0.00435f
C43 Vdd.n9 Vss 0.00148f
C44 Vdd.n10 Vss 0.00148f
C45 Vdd.n11 Vss 0.00486f
C46 Vdd.n12 Vss 0.02243f
C47 Vdd.n13 Vss 0.00717f
C48 Vdd.n14 Vss 0.00435f
C49 Vdd.n15 Vss 0.04034f
C50 Vdd.n16 Vss 0.00435f
C51 Vdd.n17 Vss 0.00148f
C52 Vdd.n18 Vss 0.00442f
C53 Vdd.n19 Vss 0.01544f
C54 Vdd.n20 Vss 0.00838f
C55 Vdd.n21 Vss 0.00182f
C56 Vdd.n22 Vss 0.00182f
C57 Vdd.n23 Vss 0.00131f
C58 Vdd.n24 Vss 0.00605f
C59 Vdd.n25 Vss 0.06645f
C60 Vdd.n27 Vss 0.00605f
C61 Vdd.n28 Vss 0.00131f
C62 Vdd.n29 Vss 0.00182f
C63 Vdd.n30 Vss 0.00182f
C64 Vdd.n31 Vss 0.00378f
C65 Vdd.n32 Vss 0.00131f
C66 Vdd.n33 Vss 0.00131f
C67 Vdd.n35 Vss 0.04519f
C68 Vdd.n37 Vss 0.00378f
C69 Vdd.n38 Vss 0.00148f
C70 Vdd.n39 Vss 0.0044f
C71 Vdd.n40 Vss 0.00182f
C72 Vdd.n41 Vss 0.00182f
C73 Vdd.n42 Vss 0.00182f
C74 Vdd.n43 Vss 0.00148f
C75 Vdd.n44 Vss 0.0044f
C76 Vdd.n45 Vss 0.01935f
C77 Vdd.n46 Vss 0.00182f
C78 Vdd.n47 Vss 0.00465f
C79 Vdd.n48 Vss 0.00148f
C80 Vdd.n49 Vss 0.00378f
C81 Vdd.n50 Vss 0.04519f
C82 Vdd.n51 Vss 0.00378f
C83 Vdd.n52 Vss 0.00148f
C84 Vdd.n53 Vss 0.00407f
C85 Vdd.n54 Vss 0.01163f
C86 Vdd.n55 Vss 0.07467f
C87 Vdd.n56 Vss 0.00838f
C88 Vdd.n57 Vss 0.00182f
C89 Vdd.n58 Vss 0.00182f
C90 Vdd.n59 Vss 0.00131f
C91 Vdd.n60 Vss 0.00605f
C92 Vdd.n61 Vss 0.06645f
C93 Vdd.n63 Vss 0.00605f
C94 Vdd.n64 Vss 0.00131f
C95 Vdd.n65 Vss 0.00182f
C96 Vdd.n66 Vss 0.00182f
C97 Vdd.n67 Vss 0.00378f
C98 Vdd.n68 Vss 0.00131f
C99 Vdd.n69 Vss 0.00131f
C100 Vdd.n71 Vss 0.04519f
C101 Vdd.n73 Vss 0.00378f
C102 Vdd.n74 Vss 0.00148f
C103 Vdd.n75 Vss 0.0044f
C104 Vdd.n76 Vss 0.00182f
C105 Vdd.n77 Vss 0.00182f
C106 Vdd.n78 Vss 0.00182f
C107 Vdd.n79 Vss 0.00148f
C108 Vdd.n80 Vss 0.0044f
C109 Vdd.n81 Vss 0.01935f
C110 Vdd.n82 Vss 0.00182f
C111 Vdd.n83 Vss 0.00465f
C112 Vdd.n84 Vss 0.00148f
C113 Vdd.n85 Vss 0.00378f
C114 Vdd.n86 Vss 0.04519f
C115 Vdd.n87 Vss 0.00378f
C116 Vdd.n88 Vss 0.00148f
C117 Vdd.n89 Vss 0.00407f
C118 Vdd.n90 Vss 0.01163f
C119 Vdd.n91 Vss 0.02801f
C120 Vdd.n92 Vss 0.00994f
C121 Vdd.n93 Vss 0.00533f
C122 Vdd.n94 Vss 0.00148f
C123 Vdd.n95 Vss 0.04034f
C124 Vdd.n96 Vss 0.00435f
C125 Vdd.n97 Vss 0.00435f
C126 Vdd.n98 Vss 0.00717f
C127 Vdd.n99 Vss 0.00148f
C128 Vdd.n100 Vss 0.02243f
C129 Vdd.n101 Vss 0.00486f
C130 Vdd.n102 Vss 0.00486f
C131 Vdd.n103 Vss 0.00148f
C132 Vdd.n104 Vss 0.00435f
C133 Vdd.n105 Vss 0.04034f
C134 Vdd.n106 Vss 0.06245f
C135 Vdd.n107 Vss 0.00717f
C136 Vdd.n108 Vss 0.00435f
C137 Vdd.n109 Vss 0.00148f
C138 Vdd.n110 Vss 0.00442f
C139 Vdd.n111 Vss 0.01281f
C140 Vdd.n112 Vss 0.00838f
C141 Vdd.n113 Vss 0.00182f
C142 Vdd.n114 Vss 0.00182f
C143 Vdd.n115 Vss 0.00131f
C144 Vdd.n116 Vss 0.00605f
C145 Vdd.n117 Vss 0.06645f
C146 Vdd.n119 Vss 0.00605f
C147 Vdd.n120 Vss 0.00131f
C148 Vdd.n121 Vss 0.00182f
C149 Vdd.n122 Vss 0.00182f
C150 Vdd.n123 Vss 0.00378f
C151 Vdd.n124 Vss 0.00131f
C152 Vdd.n125 Vss 0.00131f
C153 Vdd.n127 Vss 0.04519f
C154 Vdd.n129 Vss 0.00378f
C155 Vdd.n130 Vss 0.00148f
C156 Vdd.n131 Vss 0.0044f
C157 Vdd.n132 Vss 0.00182f
C158 Vdd.n133 Vss 0.00182f
C159 Vdd.n134 Vss 0.00182f
C160 Vdd.n135 Vss 0.00148f
C161 Vdd.n136 Vss 0.0044f
C162 Vdd.n137 Vss 0.01935f
C163 Vdd.n138 Vss 0.00182f
C164 Vdd.n139 Vss 0.00465f
C165 Vdd.n140 Vss 0.00148f
C166 Vdd.n141 Vss 0.00378f
C167 Vdd.n142 Vss 0.04519f
C168 Vdd.n143 Vss 0.00378f
C169 Vdd.n144 Vss 0.00148f
C170 Vdd.n145 Vss 0.00407f
C171 Vdd.n146 Vss 0.01163f
C172 Vdd.n147 Vss 0.05547f
C173 Vdd.n148 Vss 0.00838f
C174 Vdd.n149 Vss 0.00182f
C175 Vdd.n150 Vss 0.00182f
C176 Vdd.n151 Vss 0.00131f
C177 Vdd.n152 Vss 0.00605f
C178 Vdd.n153 Vss 0.06645f
C179 Vdd.n155 Vss 0.00605f
C180 Vdd.n156 Vss 0.00131f
C181 Vdd.n157 Vss 0.00182f
C182 Vdd.n158 Vss 0.00182f
C183 Vdd.n159 Vss 0.00378f
C184 Vdd.n160 Vss 0.00131f
C185 Vdd.n161 Vss 0.00131f
C186 Vdd.n163 Vss 0.04519f
C187 Vdd.n165 Vss 0.00378f
C188 Vdd.n166 Vss 0.00148f
C189 Vdd.n167 Vss 0.0044f
C190 Vdd.n168 Vss 0.00182f
C191 Vdd.n169 Vss 0.00182f
C192 Vdd.n170 Vss 0.00182f
C193 Vdd.n171 Vss 0.00148f
C194 Vdd.n172 Vss 0.0044f
C195 Vdd.n173 Vss 0.01935f
C196 Vdd.n174 Vss 0.00182f
C197 Vdd.n175 Vss 0.00465f
C198 Vdd.n176 Vss 0.00148f
C199 Vdd.n177 Vss 0.00378f
C200 Vdd.n178 Vss 0.04519f
C201 Vdd.n179 Vss 0.00378f
C202 Vdd.n180 Vss 0.00148f
C203 Vdd.n181 Vss 0.00407f
C204 Vdd.n182 Vss 0.01163f
C205 Vdd.n183 Vss 0.03497f
C206 Vdd.n184 Vss 0.00777f
C207 Vdd.n185 Vss 0.00486f
C208 Vdd.n186 Vss 0.00148f
C209 Vdd.n187 Vss 0.00599f
C210 Vdd.n188 Vss 0.04742f
C211 Vdd.n189 Vss 0.00372f
C212 Vdd.n190 Vss 0.0047f
C213 Vdd.n191 Vss 0.03281f
C214 Vdd.n192 Vss 0.00372f
C215 Vdd.n193 Vss 0.00148f
C216 Vdd.n194 Vss 0.00148f
C217 Vdd.n195 Vss 0.0047f
C218 Vdd.n196 Vss 0.01757f
C219 Vdd.n197 Vss 0.00599f
C220 Vdd.n198 Vss 0.00372f
C221 Vdd.n199 Vss 0.03281f
C222 Vdd.n200 Vss 0.00372f
C223 Vdd.n201 Vss 0.00148f
C224 Vdd.n202 Vss 0.00442f
C225 Vdd.n203 Vss 0.01219f
C226 Vdd.n204 Vss 0.02197f
C227 Vss.n0 Vss 0.00587f
C228 Vss.n1 Vss 0.03117f
C229 Vss.n2 Vss 0.00279f
C230 Vss.n3 Vss 0.00169f
C231 Vss.n4 Vss 0
C232 Vss.n5 Vss 0.00133f
C233 Vss.n6 Vss 0.00215f
C234 Vss.n7 Vss 0.01964f
C235 Vss.n8 Vss 0.00133f
C236 Vss.n9 Vss 0.00133f
C237 Vss.n10 Vss 0.00169f
C238 Vss.n11 Vss 0
C239 Vss.n12 Vss 0
C240 Vss.n13 Vss 0.00174f
C241 Vss.n14 Vss 0.00631f
C242 Vss.n15 Vss 0.00215f
C243 Vss.n16 Vss 0.0191f
C244 Vss.n17 Vss 0.03296f
C245 Vss.n18 Vss 0.01613f
C246 Vss.n19 Vss 0.01883f
C247 Vss.n20 Vss 0.00131f
C248 Vss.n21 Vss 0.00131f
C249 Vss.n22 Vss 0.00162f
C250 Vss.n23 Vss 0
C251 Vss.n24 Vss 0
C252 Vss.n25 Vss 0
C253 Vss.n26 Vss 0
C254 Vss.n27 Vss 0
C255 Vss.n28 Vss 0
C256 Vss.n29 Vss 0
C257 Vss.n30 Vss 0
C258 Vss.n31 Vss 0
C259 Vss.n32 Vss 0
C260 Vss.n33 Vss 0
C261 Vss.n34 Vss 0
C262 Vss.n35 Vss 0
C263 Vss.n36 Vss 0
C264 Vss.n37 Vss 0.00152f
C265 Vss.n38 Vss 0
C266 Vss.n39 Vss 0.00209f
C267 Vss.n40 Vss 0.01455f
C268 Vss.n41 Vss 0.02956f
C269 Vss.n42 Vss 0
C270 Vss.n43 Vss 0
C271 Vss.n44 Vss 0
C272 Vss.n45 Vss 0
C273 Vss.n46 Vss 0
C274 Vss.n47 Vss 0.00973f
C275 Vss.n48 Vss 0
C276 Vss.n49 Vss 0
C277 Vss.n50 Vss 0
C278 Vss.n51 Vss 0
C279 Vss.n52 Vss 0
C280 Vss.n53 Vss 0.01455f
C281 Vss.n54 Vss 0
C282 Vss.n55 Vss 0
C283 Vss.n56 Vss 0
C284 Vss.n57 Vss 0
C285 Vss.n58 Vss 0
C286 Vss.n59 Vss 0
C287 Vss.n60 Vss 0
C288 Vss.n61 Vss 0
C289 Vss.n62 Vss 0
C290 Vss.n63 Vss 0.01455f
C291 Vss.n64 Vss 0.01455f
C292 Vss.n65 Vss 0
C293 Vss.n66 Vss 0.01455f
C294 Vss.n67 Vss 0
C295 Vss.n68 Vss 0
C296 Vss.n69 Vss 0
C297 Vss.n70 Vss 0
C298 Vss.n71 Vss 0
C299 Vss.n72 Vss 0
C300 Vss.n73 Vss 0
C301 Vss.n74 Vss 0.01455f
C302 Vss.n75 Vss 0.01455f
C303 Vss.n76 Vss 0
C304 Vss.n77 Vss 0.0121f
C305 Vss.n78 Vss 0
C306 Vss.n79 Vss 0
C307 Vss.n80 Vss 0
C308 Vss.n81 Vss 0
C309 Vss.n82 Vss 0
C310 Vss.n83 Vss 0
C311 Vss.n84 Vss 0
C312 Vss.n85 Vss 0.01455f
C313 Vss.n86 Vss 0.01455f
C314 Vss.n87 Vss 0
C315 Vss.n88 Vss 0.01455f
C316 Vss.n89 Vss 0
C317 Vss.n90 Vss 0
C318 Vss.n91 Vss 0
C319 Vss.n92 Vss 0
C320 Vss.n93 Vss 0.00278f
C321 Vss.n94 Vss 0.00162f
C322 Vss.n95 Vss 0
C323 Vss.n96 Vss 0.00131f
C324 Vss.n97 Vss 0.01883f
C325 Vss.n98 Vss 0.00131f
C326 Vss.n99 Vss 0
C327 Vss.n100 Vss 0
C328 Vss.n101 Vss 0
C329 Vss.n102 Vss 0
C330 Vss.n103 Vss 0
C331 Vss.n104 Vss 0
C332 Vss.n105 Vss 0
C333 Vss.n106 Vss 0
C334 Vss.n107 Vss 0
C335 Vss.n108 Vss 0
C336 Vss.n109 Vss 0
C337 Vss.n110 Vss 0
C338 Vss.n111 Vss 0
C339 Vss.n112 Vss 0
C340 Vss.n113 Vss 0
C341 Vss.n114 Vss 0
C342 Vss.n115 Vss 0
C343 Vss.n116 Vss 0
C344 Vss.n117 Vss 0
C345 Vss.n118 Vss 0
C346 Vss.n119 Vss 0.00162f
C347 Vss.n120 Vss 0.00382f
C348 Vss.n121 Vss 0.00209f
C349 Vss.n122 Vss 0.20983f
C350 Vss.n123 Vss 0.12952f
C351 Vss.n124 Vss 0.06809f
C352 Vss.n125 Vss 0.06809f
C353 Vss.n126 Vss 0.01964f
C354 Vss.n127 Vss 0.00133f
C355 Vss.n128 Vss 0.00133f
C356 Vss.n129 Vss 0.00174f
C357 Vss.n130 Vss 0.00159f
C358 Vss.n131 Vss 0.00215f
C359 Vss.n132 Vss 0
C360 Vss.n133 Vss 0.00274f
C361 Vss.n134 Vss 0.00279f
C362 Vss.n135 Vss 0.00169f
C363 Vss.n136 Vss 0
C364 Vss.n137 Vss 0.00133f
C365 Vss.n138 Vss 0.02041f
C366 Vss.n139 Vss 0.00131f
C367 Vss.n140 Vss 0.00131f
C368 Vss.n141 Vss 0.00162f
C369 Vss.n142 Vss 0
C370 Vss.n143 Vss 0
C371 Vss.n144 Vss 0
C372 Vss.n145 Vss 0
C373 Vss.n146 Vss 0
C374 Vss.n147 Vss 0.01391f
C375 Vss.n148 Vss 0.01455f
C376 Vss.n149 Vss 0.01455f
C377 Vss.n150 Vss 0
C378 Vss.n151 Vss 0
C379 Vss.n152 Vss 0
C380 Vss.n153 Vss 0
C381 Vss.n154 Vss 0
C382 Vss.n155 Vss 0
C383 Vss.n156 Vss 0
C384 Vss.n157 Vss 0
C385 Vss.n158 Vss 0
C386 Vss.n159 Vss 0
C387 Vss.n160 Vss 0
C388 Vss.n161 Vss 0
C389 Vss.n162 Vss 0
C390 Vss.n163 Vss 0.01455f
C391 Vss.n164 Vss 0
C392 Vss.n165 Vss 0
C393 Vss.n166 Vss 0
C394 Vss.n167 Vss 0
C395 Vss.n168 Vss 0
C396 Vss.n169 Vss 0
C397 Vss.n170 Vss 0
C398 Vss.n171 Vss 0
C399 Vss.n172 Vss 0.07074f
C400 Vss.n173 Vss 0.09073f
C401 Vss.n174 Vss 0
C402 Vss.n175 Vss 0
C403 Vss.n176 Vss 0.01455f
C404 Vss.n177 Vss 0
C405 Vss.n178 Vss 0
C406 Vss.n179 Vss 0
C407 Vss.n180 Vss 0
C408 Vss.n181 Vss 0
C409 Vss.n182 Vss 0
C410 Vss.n183 Vss 0.00131f
C411 Vss.n184 Vss 0
C412 Vss.n185 Vss 0.00131f
C413 Vss.n186 Vss 0.00162f
C414 Vss.n187 Vss 0
C415 Vss.n188 Vss 0
C416 Vss.n189 Vss 0
C417 Vss.n190 Vss 0
C418 Vss.n191 Vss 0
C419 Vss.n192 Vss 0
C420 Vss.n193 Vss 0
C421 Vss.n194 Vss 0
C422 Vss.n195 Vss 0
C423 Vss.n196 Vss 0
C424 Vss.n197 Vss 0
C425 Vss.n198 Vss 0
C426 Vss.n199 Vss 0
C427 Vss.n200 Vss 0
C428 Vss.n201 Vss 0
C429 Vss.n202 Vss 0
C430 Vss.n203 Vss 0
C431 Vss.n204 Vss 0
C432 Vss.n205 Vss 0
C433 Vss.n206 Vss 0
C434 Vss.n207 Vss 0
C435 Vss.n208 Vss 0
C436 Vss.n209 Vss 0.00152f
C437 Vss.n210 Vss 0.00645f
C438 Vss.n211 Vss 0.00278f
C439 Vss.n212 Vss 0.00209f
C440 Vss.n213 Vss 0.07809f
C441 Vss.n214 Vss 0.01883f
C442 Vss.n215 Vss 0.01455f
C443 Vss.n216 Vss 0
C444 Vss.n217 Vss 0
C445 Vss.n218 Vss 0
C446 Vss.n219 Vss 0
C447 Vss.n220 Vss 0
C448 Vss.n221 Vss 0.01455f
C449 Vss.n222 Vss 0.011f
C450 Vss.n223 Vss 0.01613f
C451 Vss.n224 Vss 0.01082f
C452 Vss.n225 Vss 0
C453 Vss.n226 Vss 0
C454 Vss.n227 Vss 0
C455 Vss.n228 Vss 0
C456 Vss.n229 Vss 0
C457 Vss.n230 Vss 0.01455f
C458 Vss.n231 Vss 0.01455f
C459 Vss.n232 Vss 0.01455f
C460 Vss.n233 Vss 0
C461 Vss.n234 Vss 0
C462 Vss.n235 Vss 0
C463 Vss.n236 Vss 0
C464 Vss.n237 Vss 0
C465 Vss.n238 Vss 0.01455f
C466 Vss.n239 Vss 0
C467 Vss.n240 Vss 0
C468 Vss.n241 Vss 0
C469 Vss.n242 Vss 0
C470 Vss.n243 Vss 0.00162f
C471 Vss.n244 Vss 0.00382f
C472 Vss.n245 Vss 0.00209f
C473 Vss.n246 Vss 0.02965f
C474 Vss.n247 Vss 0.03711f
C475 Vss.n248 Vss 0.01964f
C476 Vss.n249 Vss 0.00133f
C477 Vss.n250 Vss 0
C478 Vss.n251 Vss 0
C479 Vss.n252 Vss 0.00169f
C480 Vss.n253 Vss 0.00631f
C481 Vss.n254 Vss 0.00215f
C482 Vss.n255 Vss 0.0191f
C483 Vss.n256 Vss 0.03296f
C484 Vss.n257 Vss 0.03038f
C485 Vss.n258 Vss 0.01964f
C486 Vss.n259 Vss 0.00133f
C487 Vss.n260 Vss 0
C488 Vss.n261 Vss 0.00159f
C489 Vss.n262 Vss 0.00274f
C490 Vss.n263 Vss 0.0061f
C491 Vin.n0 Vss 0.00994f
C492 Vin_neg.n0 Vss 0.02403f
C493 Iex_1_i Vss -0.05753f
C494 Iex_3_i Vss -0.04057f
C495 Vin Vss -0.04735f
C496 xm4_0/a_28_n281# Vss -1.9006f
C497 Vin_neg Vss -0.02343f
C498 Iex_2_i Vss -0.04945f
C499 xm9_0/a_28_n131# Vss -0.51086f
C500 Iex_4_i Vss -0.04509f
C501 xm9_0/a_n50_n339# Vss -0.72525f
C502 Vdd Vss -13.92535f
C503 xm3_0/a_28_n281# Vss -1.41331f
R0 Vss.n213 Vss.n173 16945.1
R1 Vss.n123 Vss.n122 11700.7
R2 Vss.n123 Vss.n18 10887.5
R3 Vss.n223 Vss.n173 10887.5
R4 Vss.n172 Vss.n138 10887.5
R5 Vss.n256 Vss.n125 10111.1
R6 Vss.n124 Vss.n17 10111.1
R7 Vss.n173 Vss.n172 4830.04
R8 Vss.n124 Vss.n123 4784.76
R9 Vss.n172 Vss.n125 4784.76
R10 Vss.n125 Vss.n124 3693.99
R11 Vss.n247 Vss.n246 793.182
R12 Vss.n41 Vss.n17 577.389
R13 Vss.n257 Vss.n256 577.389
R14 Vss.n16 Vss.n7 396.591
R15 Vss.n258 Vss.n257 396.591
R16 Vss.n255 Vss.n126 396.591
R17 Vss.n248 Vss.n247 396.591
R18 Vss.n122 Vss.n19 370.346
R19 Vss.n97 Vss.n41 370.346
R20 Vss.n214 Vss.n213 370.346
R21 Vss.n63 Vss.n19 233.288
R22 Vss.n64 Vss.n63 233.288
R23 Vss.n66 Vss.n64 233.288
R24 Vss.n66 Vss.n53 233.288
R25 Vss.n74 Vss.n53 233.288
R26 Vss.n75 Vss.n74 233.288
R27 Vss.n77 Vss.n75 233.288
R28 Vss.n85 Vss.n47 233.288
R29 Vss.n86 Vss.n85 233.288
R30 Vss.n88 Vss.n86 233.288
R31 Vss.n88 Vss.n40 233.288
R32 Vss.n97 Vss.n40 233.288
R33 Vss.n258 Vss.n7 233.288
R34 Vss.n248 Vss.n126 233.288
R35 Vss.n148 Vss.n147 233.288
R36 Vss.n238 Vss.n148 233.288
R37 Vss.n238 Vss.n149 233.288
R38 Vss.n232 Vss.n149 233.288
R39 Vss.n232 Vss.n231 233.288
R40 Vss.n231 Vss.n230 233.288
R41 Vss.n230 Vss.n163 233.288
R42 Vss.n224 Vss.n163 233.288
R43 Vss.n222 Vss.n221 233.288
R44 Vss.n221 Vss.n176 233.288
R45 Vss.n215 Vss.n176 233.288
R46 Vss.n215 Vss.n214 233.288
R47 Vss.n17 Vss.n16 215.792
R48 Vss.n256 Vss.n255 215.792
R49 Vss.n147 Vss.n138 212.876
R50 Vss.n246 Vss.n138 157.47
R51 Vss.n77 Vss.n18 154.554
R52 Vss.n223 Vss.n222 119.561
R53 Vss.n224 Vss.n223 113.728
R54 Vss.n47 Vss.n18 78.7354
R55 Vss.n137 Vss.n131 68.4449
R56 Vss.n249 Vss.n131 68.4449
R57 Vss.n254 Vss.n128 68.4449
R58 Vss.n254 Vss.n127 68.4449
R59 Vss.n8 Vss.n6 68.4449
R60 Vss.n259 Vss.n6 68.4449
R61 Vss.n15 Vss.n5 68.4449
R62 Vss.n15 Vss.n9 68.4449
R63 Vss.n245 Vss.n139 66.6949
R64 Vss.n212 Vss.n183 66.6949
R65 Vss.n212 Vss.n185 66.6949
R66 Vss.n245 Vss.n140 66.6949
R67 Vss.n121 Vss.n20 66.6949
R68 Vss.n121 Vss.n21 66.6949
R69 Vss.n96 Vss.n39 66.6949
R70 Vss.n98 Vss.n39 66.6949
R71 Vss.n150 Vss.n139 15.5561
R72 Vss.n237 Vss.n150 15.5561
R73 Vss.n237 Vss.n151 15.5561
R74 Vss.n233 Vss.n151 15.5561
R75 Vss.n233 Vss.n159 15.5561
R76 Vss.n229 Vss.n159 15.5561
R77 Vss.n229 Vss.n164 15.5561
R78 Vss.n225 Vss.n164 15.5561
R79 Vss.n225 Vss.n170 15.5561
R80 Vss.n220 Vss.n170 15.5561
R81 Vss.n220 Vss.n177 15.5561
R82 Vss.n216 Vss.n177 15.5561
R83 Vss.n216 Vss.n183 15.5561
R84 Vss.n143 Vss.n140 15.5561
R85 Vss.n239 Vss.n143 15.5561
R86 Vss.n239 Vss.n146 15.5561
R87 Vss.n160 Vss.n146 15.5561
R88 Vss.n161 Vss.n160 15.5561
R89 Vss.n162 Vss.n161 15.5561
R90 Vss.n198 Vss.n162 15.5561
R91 Vss.n198 Vss.n171 15.5561
R92 Vss.n174 Vss.n171 15.5561
R93 Vss.n175 Vss.n174 15.5561
R94 Vss.n205 Vss.n175 15.5561
R95 Vss.n205 Vss.n184 15.5561
R96 Vss.n185 Vss.n184 15.5561
R97 Vss.n249 Vss.n128 15.5561
R98 Vss.n137 Vss.n127 15.5561
R99 Vss.n259 Vss.n5 15.5561
R100 Vss.n9 Vss.n8 15.5561
R101 Vss.n62 Vss.n20 15.5561
R102 Vss.n62 Vss.n58 15.5561
R103 Vss.n67 Vss.n58 15.5561
R104 Vss.n67 Vss.n54 15.5561
R105 Vss.n73 Vss.n54 15.5561
R106 Vss.n73 Vss.n52 15.5561
R107 Vss.n78 Vss.n52 15.5561
R108 Vss.n78 Vss.n48 15.5561
R109 Vss.n84 Vss.n48 15.5561
R110 Vss.n84 Vss.n46 15.5561
R111 Vss.n89 Vss.n46 15.5561
R112 Vss.n89 Vss.n42 15.5561
R113 Vss.n96 Vss.n42 15.5561
R114 Vss.n24 Vss.n21 15.5561
R115 Vss.n25 Vss.n24 15.5561
R116 Vss.n65 Vss.n25 15.5561
R117 Vss.n65 Vss.n28 15.5561
R118 Vss.n29 Vss.n28 15.5561
R119 Vss.n30 Vss.n29 15.5561
R120 Vss.n76 Vss.n30 15.5561
R121 Vss.n76 Vss.n33 15.5561
R122 Vss.n34 Vss.n33 15.5561
R123 Vss.n35 Vss.n34 15.5561
R124 Vss.n87 Vss.n35 15.5561
R125 Vss.n87 Vss.n38 15.5561
R126 Vss.n98 Vss.n38 15.5561
R127 Vss.n210 Vss.n1 6.43229
R128 Vss Vss.n0 5.48009
R129 Vss.n11 Vss.n8 5.2005
R130 Vss.n258 Vss.n8 5.2005
R131 Vss.n12 Vss.n9 5.2005
R132 Vss.n9 Vss.n7 5.2005
R133 Vss.n260 Vss.n259 5.2005
R134 Vss.n259 Vss.n258 5.2005
R135 Vss.n5 Vss.n4 5.2005
R136 Vss.n7 Vss.n5 5.2005
R137 Vss.n137 Vss.n136 5.2005
R138 Vss.n248 Vss.n137 5.2005
R139 Vss.n132 Vss.n127 5.2005
R140 Vss.n127 Vss.n126 5.2005
R141 Vss.n250 Vss.n249 5.2005
R142 Vss.n249 Vss.n248 5.2005
R143 Vss.n251 Vss.n128 5.2005
R144 Vss.n128 Vss.n126 5.2005
R145 Vss.n208 Vss.n185 5.2005
R146 Vss.n214 Vss.n185 5.2005
R147 Vss.n207 Vss.n184 5.2005
R148 Vss.n215 Vss.n184 5.2005
R149 Vss.n206 Vss.n205 5.2005
R150 Vss.n205 Vss.n176 5.2005
R151 Vss.n188 Vss.n175 5.2005
R152 Vss.n221 Vss.n175 5.2005
R153 Vss.n201 Vss.n174 5.2005
R154 Vss.n222 Vss.n174 5.2005
R155 Vss.n200 Vss.n171 5.2005
R156 Vss.n224 Vss.n171 5.2005
R157 Vss.n199 Vss.n198 5.2005
R158 Vss.n198 Vss.n163 5.2005
R159 Vss.n190 Vss.n162 5.2005
R160 Vss.n230 Vss.n162 5.2005
R161 Vss.n194 Vss.n161 5.2005
R162 Vss.n231 Vss.n161 5.2005
R163 Vss.n193 Vss.n160 5.2005
R164 Vss.n232 Vss.n160 5.2005
R165 Vss.n146 Vss.n145 5.2005
R166 Vss.n149 Vss.n146 5.2005
R167 Vss.n240 Vss.n239 5.2005
R168 Vss.n239 Vss.n238 5.2005
R169 Vss.n241 Vss.n143 5.2005
R170 Vss.n148 Vss.n143 5.2005
R171 Vss.n242 Vss.n140 5.2005
R172 Vss.n147 Vss.n140 5.2005
R173 Vss.n152 Vss.n139 5.2005
R174 Vss.n147 Vss.n139 5.2005
R175 Vss.n153 Vss.n150 5.2005
R176 Vss.n150 Vss.n148 5.2005
R177 Vss.n237 Vss.n236 5.2005
R178 Vss.n238 Vss.n237 5.2005
R179 Vss.n235 Vss.n151 5.2005
R180 Vss.n151 Vss.n149 5.2005
R181 Vss.n234 Vss.n233 5.2005
R182 Vss.n233 Vss.n232 5.2005
R183 Vss.n159 Vss.n158 5.2005
R184 Vss.n231 Vss.n159 5.2005
R185 Vss.n229 Vss.n228 5.2005
R186 Vss.n230 Vss.n229 5.2005
R187 Vss.n227 Vss.n164 5.2005
R188 Vss.n164 Vss.n163 5.2005
R189 Vss.n226 Vss.n225 5.2005
R190 Vss.n225 Vss.n224 5.2005
R191 Vss.n170 Vss.n169 5.2005
R192 Vss.n222 Vss.n170 5.2005
R193 Vss.n220 Vss.n219 5.2005
R194 Vss.n221 Vss.n220 5.2005
R195 Vss.n218 Vss.n177 5.2005
R196 Vss.n177 Vss.n176 5.2005
R197 Vss.n217 Vss.n216 5.2005
R198 Vss.n216 Vss.n215 5.2005
R199 Vss.n183 Vss.n182 5.2005
R200 Vss.n214 Vss.n183 5.2005
R201 Vss.n96 Vss.n95 5.2005
R202 Vss.n97 Vss.n96 5.2005
R203 Vss.n43 Vss.n42 5.2005
R204 Vss.n42 Vss.n40 5.2005
R205 Vss.n90 Vss.n89 5.2005
R206 Vss.n89 Vss.n88 5.2005
R207 Vss.n46 Vss.n45 5.2005
R208 Vss.n86 Vss.n46 5.2005
R209 Vss.n84 Vss.n83 5.2005
R210 Vss.n85 Vss.n84 5.2005
R211 Vss.n49 Vss.n48 5.2005
R212 Vss.n48 Vss.n47 5.2005
R213 Vss.n79 Vss.n78 5.2005
R214 Vss.n78 Vss.n77 5.2005
R215 Vss.n52 Vss.n51 5.2005
R216 Vss.n75 Vss.n52 5.2005
R217 Vss.n73 Vss.n72 5.2005
R218 Vss.n74 Vss.n73 5.2005
R219 Vss.n55 Vss.n54 5.2005
R220 Vss.n54 Vss.n53 5.2005
R221 Vss.n68 Vss.n67 5.2005
R222 Vss.n67 Vss.n66 5.2005
R223 Vss.n58 Vss.n57 5.2005
R224 Vss.n64 Vss.n58 5.2005
R225 Vss.n62 Vss.n61 5.2005
R226 Vss.n63 Vss.n62 5.2005
R227 Vss.n59 Vss.n20 5.2005
R228 Vss.n20 Vss.n19 5.2005
R229 Vss.n99 Vss.n98 5.2005
R230 Vss.n98 Vss.n97 5.2005
R231 Vss.n100 Vss.n38 5.2005
R232 Vss.n40 Vss.n38 5.2005
R233 Vss.n87 Vss.n36 5.2005
R234 Vss.n88 Vss.n87 5.2005
R235 Vss.n104 Vss.n35 5.2005
R236 Vss.n86 Vss.n35 5.2005
R237 Vss.n105 Vss.n34 5.2005
R238 Vss.n85 Vss.n34 5.2005
R239 Vss.n106 Vss.n33 5.2005
R240 Vss.n47 Vss.n33 5.2005
R241 Vss.n76 Vss.n31 5.2005
R242 Vss.n77 Vss.n76 5.2005
R243 Vss.n110 Vss.n30 5.2005
R244 Vss.n75 Vss.n30 5.2005
R245 Vss.n111 Vss.n29 5.2005
R246 Vss.n74 Vss.n29 5.2005
R247 Vss.n112 Vss.n28 5.2005
R248 Vss.n53 Vss.n28 5.2005
R249 Vss.n65 Vss.n26 5.2005
R250 Vss.n66 Vss.n65 5.2005
R251 Vss.n116 Vss.n25 5.2005
R252 Vss.n64 Vss.n25 5.2005
R253 Vss.n117 Vss.n24 5.2005
R254 Vss.n63 Vss.n24 5.2005
R255 Vss.n118 Vss.n21 5.2005
R256 Vss.n21 Vss.n19 5.2005
R257 Vss.n135 Vss.n134 5.19561
R258 Vss.n253 Vss.n252 5.19561
R259 Vss.n10 Vss.n2 5.19561
R260 Vss.n14 Vss.n3 5.19561
R261 Vss.n253 Vss.n129 5.18779
R262 Vss.n14 Vss.n13 5.18779
R263 Vss.n244 Vss.n141 5.17941
R264 Vss.n211 Vss.n186 5.17941
R265 Vss.n244 Vss.n243 5.17941
R266 Vss.n120 Vss.n119 5.17941
R267 Vss.n120 Vss.n22 5.17941
R268 Vss.n94 Vss.n93 5.17941
R269 Vss.n133 Vss.n1 5.02289
R270 Vss.n263 Vss.n262 5.02289
R271 Vss.n133 Vss.n130 4.7417
R272 Vss.n262 Vss.n261 4.7417
R273 Vss.n210 Vss.n209 4.7255
R274 Vss.n37 Vss.n0 4.7255
R275 Vss.n152 Vss.n141 4.5005
R276 Vss.n154 Vss.n153 4.5005
R277 Vss.n236 Vss.n155 4.5005
R278 Vss.n235 Vss.n156 4.5005
R279 Vss.n234 Vss.n157 4.5005
R280 Vss.n165 Vss.n158 4.5005
R281 Vss.n228 Vss.n166 4.5005
R282 Vss.n227 Vss.n167 4.5005
R283 Vss.n226 Vss.n168 4.5005
R284 Vss.n178 Vss.n169 4.5005
R285 Vss.n219 Vss.n179 4.5005
R286 Vss.n218 Vss.n180 4.5005
R287 Vss.n217 Vss.n181 4.5005
R288 Vss.n186 Vss.n182 4.5005
R289 Vss.n241 Vss.n142 4.5005
R290 Vss.n240 Vss.n144 4.5005
R291 Vss.n191 Vss.n145 4.5005
R292 Vss.n193 Vss.n192 4.5005
R293 Vss.n195 Vss.n194 4.5005
R294 Vss.n196 Vss.n190 4.5005
R295 Vss.n199 Vss.n197 4.5005
R296 Vss.n200 Vss.n189 4.5005
R297 Vss.n202 Vss.n201 4.5005
R298 Vss.n203 Vss.n188 4.5005
R299 Vss.n206 Vss.n204 4.5005
R300 Vss.n207 Vss.n187 4.5005
R301 Vss.n209 Vss.n208 4.5005
R302 Vss.n243 Vss.n242 4.5005
R303 Vss.n250 Vss.n130 4.5005
R304 Vss.n252 Vss.n251 4.5005
R305 Vss.n136 Vss.n135 4.5005
R306 Vss.n132 Vss.n129 4.5005
R307 Vss.n261 Vss.n260 4.5005
R308 Vss.n4 Vss.n3 4.5005
R309 Vss.n11 Vss.n10 4.5005
R310 Vss.n13 Vss.n12 4.5005
R311 Vss.n117 Vss.n23 4.5005
R312 Vss.n116 Vss.n115 4.5005
R313 Vss.n114 Vss.n26 4.5005
R314 Vss.n113 Vss.n112 4.5005
R315 Vss.n111 Vss.n27 4.5005
R316 Vss.n110 Vss.n109 4.5005
R317 Vss.n108 Vss.n31 4.5005
R318 Vss.n107 Vss.n106 4.5005
R319 Vss.n105 Vss.n32 4.5005
R320 Vss.n104 Vss.n103 4.5005
R321 Vss.n102 Vss.n36 4.5005
R322 Vss.n101 Vss.n100 4.5005
R323 Vss.n99 Vss.n37 4.5005
R324 Vss.n119 Vss.n118 4.5005
R325 Vss.n61 Vss.n60 4.5005
R326 Vss.n57 Vss.n56 4.5005
R327 Vss.n69 Vss.n68 4.5005
R328 Vss.n70 Vss.n55 4.5005
R329 Vss.n72 Vss.n71 4.5005
R330 Vss.n51 Vss.n50 4.5005
R331 Vss.n80 Vss.n79 4.5005
R332 Vss.n81 Vss.n49 4.5005
R333 Vss.n83 Vss.n82 4.5005
R334 Vss.n45 Vss.n44 4.5005
R335 Vss.n91 Vss.n90 4.5005
R336 Vss.n92 Vss.n43 4.5005
R337 Vss.n95 Vss.n94 4.5005
R338 Vss.n59 Vss.n22 4.5005
R339 Vss.n15 Vss.n14 0.743357
R340 Vss.n16 Vss.n15 0.743357
R341 Vss.n6 Vss.n2 0.743357
R342 Vss.n257 Vss.n6 0.743357
R343 Vss.n254 Vss.n253 0.743357
R344 Vss.n255 Vss.n254 0.743357
R345 Vss.n134 Vss.n131 0.743357
R346 Vss.n247 Vss.n131 0.743357
R347 Vss.n245 Vss.n244 0.743357
R348 Vss.n246 Vss.n245 0.743357
R349 Vss.n212 Vss.n211 0.743357
R350 Vss.n213 Vss.n212 0.743357
R351 Vss.n121 Vss.n120 0.743357
R352 Vss.n122 Vss.n121 0.743357
R353 Vss.n93 Vss.n39 0.743357
R354 Vss.n41 Vss.n39 0.743357
R355 Vss.n263 Vss.n1 0.5621
R356 Vss.n211 Vss.n210 0.454413
R357 Vss.n134 Vss.n133 0.454413
R358 Vss.n262 Vss.n2 0.454413
R359 Vss.n93 Vss.n0 0.454413
R360 Vss.n242 Vss.n241 0.1445
R361 Vss.n241 Vss.n240 0.1445
R362 Vss.n240 Vss.n145 0.1445
R363 Vss.n193 Vss.n145 0.1445
R364 Vss.n194 Vss.n193 0.1445
R365 Vss.n194 Vss.n190 0.1445
R366 Vss.n199 Vss.n190 0.1445
R367 Vss.n200 Vss.n199 0.1445
R368 Vss.n201 Vss.n200 0.1445
R369 Vss.n201 Vss.n188 0.1445
R370 Vss.n206 Vss.n188 0.1445
R371 Vss.n207 Vss.n206 0.1445
R372 Vss.n208 Vss.n207 0.1445
R373 Vss.n153 Vss.n152 0.1445
R374 Vss.n236 Vss.n153 0.1445
R375 Vss.n236 Vss.n235 0.1445
R376 Vss.n235 Vss.n234 0.1445
R377 Vss.n234 Vss.n158 0.1445
R378 Vss.n228 Vss.n158 0.1445
R379 Vss.n228 Vss.n227 0.1445
R380 Vss.n227 Vss.n226 0.1445
R381 Vss.n226 Vss.n169 0.1445
R382 Vss.n219 Vss.n169 0.1445
R383 Vss.n219 Vss.n218 0.1445
R384 Vss.n218 Vss.n217 0.1445
R385 Vss.n217 Vss.n182 0.1445
R386 Vss.n154 Vss.n141 0.1445
R387 Vss.n155 Vss.n154 0.1445
R388 Vss.n156 Vss.n155 0.1445
R389 Vss.n157 Vss.n156 0.1445
R390 Vss.n165 Vss.n157 0.1445
R391 Vss.n166 Vss.n165 0.1445
R392 Vss.n167 Vss.n166 0.1445
R393 Vss.n168 Vss.n167 0.1445
R394 Vss.n178 Vss.n168 0.1445
R395 Vss.n179 Vss.n178 0.1445
R396 Vss.n180 Vss.n179 0.1445
R397 Vss.n181 Vss.n180 0.1445
R398 Vss.n186 Vss.n181 0.1445
R399 Vss.n243 Vss.n142 0.1445
R400 Vss.n144 Vss.n142 0.1445
R401 Vss.n191 Vss.n144 0.1445
R402 Vss.n192 Vss.n191 0.1445
R403 Vss.n195 Vss.n192 0.1445
R404 Vss.n196 Vss.n195 0.1445
R405 Vss.n197 Vss.n196 0.1445
R406 Vss.n197 Vss.n189 0.1445
R407 Vss.n202 Vss.n189 0.1445
R408 Vss.n203 Vss.n202 0.1445
R409 Vss.n204 Vss.n203 0.1445
R410 Vss.n204 Vss.n187 0.1445
R411 Vss.n209 Vss.n187 0.1445
R412 Vss.n251 Vss.n250 0.1445
R413 Vss.n252 Vss.n130 0.1445
R414 Vss.n135 Vss.n129 0.1445
R415 Vss.n136 Vss.n132 0.1445
R416 Vss.n260 Vss.n4 0.1445
R417 Vss.n261 Vss.n3 0.1445
R418 Vss.n13 Vss.n10 0.1445
R419 Vss.n12 Vss.n11 0.1445
R420 Vss.n61 Vss.n59 0.1445
R421 Vss.n61 Vss.n57 0.1445
R422 Vss.n68 Vss.n57 0.1445
R423 Vss.n68 Vss.n55 0.1445
R424 Vss.n72 Vss.n55 0.1445
R425 Vss.n72 Vss.n51 0.1445
R426 Vss.n79 Vss.n51 0.1445
R427 Vss.n79 Vss.n49 0.1445
R428 Vss.n83 Vss.n49 0.1445
R429 Vss.n83 Vss.n45 0.1445
R430 Vss.n90 Vss.n45 0.1445
R431 Vss.n90 Vss.n43 0.1445
R432 Vss.n95 Vss.n43 0.1445
R433 Vss.n118 Vss.n117 0.1445
R434 Vss.n117 Vss.n116 0.1445
R435 Vss.n116 Vss.n26 0.1445
R436 Vss.n112 Vss.n26 0.1445
R437 Vss.n112 Vss.n111 0.1445
R438 Vss.n111 Vss.n110 0.1445
R439 Vss.n110 Vss.n31 0.1445
R440 Vss.n106 Vss.n31 0.1445
R441 Vss.n106 Vss.n105 0.1445
R442 Vss.n105 Vss.n104 0.1445
R443 Vss.n104 Vss.n36 0.1445
R444 Vss.n100 Vss.n36 0.1445
R445 Vss.n100 Vss.n99 0.1445
R446 Vss.n119 Vss.n23 0.1445
R447 Vss.n115 Vss.n23 0.1445
R448 Vss.n115 Vss.n114 0.1445
R449 Vss.n114 Vss.n113 0.1445
R450 Vss.n113 Vss.n27 0.1445
R451 Vss.n109 Vss.n27 0.1445
R452 Vss.n109 Vss.n108 0.1445
R453 Vss.n108 Vss.n107 0.1445
R454 Vss.n107 Vss.n32 0.1445
R455 Vss.n103 Vss.n32 0.1445
R456 Vss.n103 Vss.n102 0.1445
R457 Vss.n102 Vss.n101 0.1445
R458 Vss.n101 Vss.n37 0.1445
R459 Vss.n60 Vss.n22 0.1445
R460 Vss.n60 Vss.n56 0.1445
R461 Vss.n69 Vss.n56 0.1445
R462 Vss.n70 Vss.n69 0.1445
R463 Vss.n71 Vss.n70 0.1445
R464 Vss.n71 Vss.n50 0.1445
R465 Vss.n80 Vss.n50 0.1445
R466 Vss.n81 Vss.n80 0.1445
R467 Vss.n82 Vss.n81 0.1445
R468 Vss.n82 Vss.n44 0.1445
R469 Vss.n91 Vss.n44 0.1445
R470 Vss.n92 Vss.n91 0.1445
R471 Vss.n94 Vss.n92 0.1445
R472 Vss Vss.n263 0.1013
R473 Vdd.n106 Vdd.n95 696.312
R474 Vdd.n106 Vdd.n105 696.312
R475 Vdd.n15 Vdd.n4 696.312
R476 Vdd.n7 Vdd.n4 696.312
R477 Vdd.n199 Vdd.n188 528.52
R478 Vdd.n191 Vdd.n188 528.52
R479 Vdd.n142 Vdd.n117 446.678
R480 Vdd.n127 Vdd.n117 446.678
R481 Vdd.n178 Vdd.n153 446.678
R482 Vdd.n163 Vdd.n153 446.678
R483 Vdd.n86 Vdd.n61 446.678
R484 Vdd.n71 Vdd.n61 446.678
R485 Vdd.n50 Vdd.n25 446.678
R486 Vdd.n35 Vdd.n25 446.678
R487 Vdd.n108 Vdd.n107 74.638
R488 Vdd.n107 Vdd.n96 74.638
R489 Vdd.n104 Vdd.n98 74.638
R490 Vdd.n98 Vdd.n97 74.638
R491 Vdd.n16 Vdd.n3 74.638
R492 Vdd.n8 Vdd.n3 74.638
R493 Vdd.n13 Vdd.n5 74.638
R494 Vdd.n14 Vdd.n13 74.638
R495 Vdd.n143 Vdd.n116 62.563
R496 Vdd.n129 Vdd.n116 62.563
R497 Vdd.n123 Vdd.n119 62.563
R498 Vdd.n141 Vdd.n119 62.563
R499 Vdd.n179 Vdd.n152 62.563
R500 Vdd.n165 Vdd.n152 62.563
R501 Vdd.n159 Vdd.n155 62.563
R502 Vdd.n177 Vdd.n155 62.563
R503 Vdd.n87 Vdd.n60 62.563
R504 Vdd.n73 Vdd.n60 62.563
R505 Vdd.n67 Vdd.n63 62.563
R506 Vdd.n85 Vdd.n63 62.563
R507 Vdd.n51 Vdd.n24 62.563
R508 Vdd.n37 Vdd.n24 62.563
R509 Vdd.n31 Vdd.n27 62.563
R510 Vdd.n49 Vdd.n27 62.563
R511 Vdd.n200 Vdd.n187 61.6005
R512 Vdd.n192 Vdd.n187 61.6005
R513 Vdd.n197 Vdd.n189 61.6005
R514 Vdd.n198 Vdd.n197 61.6005
R515 Vdd.n125 Vdd.n124 14.0005
R516 Vdd.n141 Vdd.n120 14.0005
R517 Vdd.n143 Vdd.n115 14.0005
R518 Vdd.n161 Vdd.n160 14.0005
R519 Vdd.n177 Vdd.n156 14.0005
R520 Vdd.n179 Vdd.n151 14.0005
R521 Vdd.n69 Vdd.n68 14.0005
R522 Vdd.n85 Vdd.n64 14.0005
R523 Vdd.n87 Vdd.n59 14.0005
R524 Vdd.n33 Vdd.n32 14.0005
R525 Vdd.n49 Vdd.n28 14.0005
R526 Vdd.n51 Vdd.n23 14.0005
R527 Vdd.n99 Vdd.n96 6.3005
R528 Vdd.n104 Vdd.n103 6.3005
R529 Vdd.n97 Vdd.n94 6.3005
R530 Vdd.n109 Vdd.n108 6.3005
R531 Vdd.n130 Vdd.n129 6.3005
R532 Vdd.n133 Vdd.n125 6.3005
R533 Vdd.n134 Vdd.n124 6.3005
R534 Vdd.n135 Vdd.n123 6.3005
R535 Vdd.n144 Vdd.n143 6.3005
R536 Vdd.n143 Vdd.n142 6.3005
R537 Vdd.n115 Vdd.n114 6.3005
R538 Vdd.n121 Vdd.n120 6.3005
R539 Vdd.n141 Vdd.n140 6.3005
R540 Vdd.n142 Vdd.n141 6.3005
R541 Vdd.n166 Vdd.n165 6.3005
R542 Vdd.n169 Vdd.n161 6.3005
R543 Vdd.n170 Vdd.n160 6.3005
R544 Vdd.n171 Vdd.n159 6.3005
R545 Vdd.n180 Vdd.n179 6.3005
R546 Vdd.n179 Vdd.n178 6.3005
R547 Vdd.n151 Vdd.n150 6.3005
R548 Vdd.n157 Vdd.n156 6.3005
R549 Vdd.n177 Vdd.n176 6.3005
R550 Vdd.n178 Vdd.n177 6.3005
R551 Vdd.n193 Vdd.n192 6.3005
R552 Vdd.n194 Vdd.n189 6.3005
R553 Vdd.n201 Vdd.n200 6.3005
R554 Vdd.n198 Vdd.n186 6.3005
R555 Vdd.n74 Vdd.n73 6.3005
R556 Vdd.n77 Vdd.n69 6.3005
R557 Vdd.n78 Vdd.n68 6.3005
R558 Vdd.n79 Vdd.n67 6.3005
R559 Vdd.n88 Vdd.n87 6.3005
R560 Vdd.n87 Vdd.n86 6.3005
R561 Vdd.n59 Vdd.n58 6.3005
R562 Vdd.n65 Vdd.n64 6.3005
R563 Vdd.n85 Vdd.n84 6.3005
R564 Vdd.n86 Vdd.n85 6.3005
R565 Vdd.n38 Vdd.n37 6.3005
R566 Vdd.n41 Vdd.n33 6.3005
R567 Vdd.n42 Vdd.n32 6.3005
R568 Vdd.n43 Vdd.n31 6.3005
R569 Vdd.n52 Vdd.n51 6.3005
R570 Vdd.n51 Vdd.n50 6.3005
R571 Vdd.n23 Vdd.n22 6.3005
R572 Vdd.n29 Vdd.n28 6.3005
R573 Vdd.n49 Vdd.n48 6.3005
R574 Vdd.n50 Vdd.n49 6.3005
R575 Vdd.n9 Vdd.n8 6.3005
R576 Vdd.n10 Vdd.n5 6.3005
R577 Vdd.n17 Vdd.n16 6.3005
R578 Vdd.n14 Vdd.n2 6.3005
R579 Vdd.n55 Vdd.n19 5.89534
R580 Vdd.n147 Vdd.n111 5.78014
R581 Vdd.n204 Vdd.n203 5.51007
R582 Vdd.n147 Vdd.n146 5.42593
R583 Vdd.n183 Vdd.n182 5.42593
R584 Vdd.n91 Vdd.n90 5.42593
R585 Vdd.n55 Vdd.n54 5.42593
R586 Vdd.n102 Vdd.n100 5.34137
R587 Vdd.n101 Vdd.n92 5.34137
R588 Vdd.n12 Vdd.n11 5.34137
R589 Vdd.n6 Vdd.n0 5.34137
R590 Vdd.n100 Vdd.n93 5.33355
R591 Vdd.n12 Vdd.n1 5.33355
R592 Vdd.n137 Vdd.n136 5.20888
R593 Vdd.n131 Vdd.n112 5.20888
R594 Vdd.n173 Vdd.n172 5.20888
R595 Vdd.n167 Vdd.n148 5.20888
R596 Vdd.n81 Vdd.n80 5.20888
R597 Vdd.n75 Vdd.n56 5.20888
R598 Vdd.n45 Vdd.n44 5.20888
R599 Vdd.n39 Vdd.n20 5.20888
R600 Vdd.n139 Vdd.n137 5.20105
R601 Vdd.n175 Vdd.n173 5.20105
R602 Vdd.n83 Vdd.n81 5.20105
R603 Vdd.n47 Vdd.n45 5.20105
R604 Vdd.n196 Vdd.n195 5.19561
R605 Vdd.n190 Vdd.n184 5.19561
R606 Vdd.n196 Vdd.n185 5.18779
R607 Vdd.n111 Vdd.n110 4.7417
R608 Vdd.n203 Vdd.n202 4.7417
R609 Vdd.n19 Vdd.n18 4.7417
R610 Vdd.n146 Vdd.n145 4.7129
R611 Vdd.n182 Vdd.n181 4.7129
R612 Vdd.n90 Vdd.n89 4.7129
R613 Vdd.n54 Vdd.n53 4.7129
R614 Vdd.n94 Vdd.n93 4.5005
R615 Vdd.n110 Vdd.n109 4.5005
R616 Vdd.n101 Vdd.n99 4.5005
R617 Vdd.n103 Vdd.n102 4.5005
R618 Vdd.n138 Vdd.n121 4.5005
R619 Vdd.n114 Vdd.n113 4.5005
R620 Vdd.n145 Vdd.n144 4.5005
R621 Vdd.n140 Vdd.n139 4.5005
R622 Vdd.n134 Vdd.n122 4.5005
R623 Vdd.n133 Vdd.n132 4.5005
R624 Vdd.n131 Vdd.n130 4.5005
R625 Vdd.n136 Vdd.n135 4.5005
R626 Vdd.n174 Vdd.n157 4.5005
R627 Vdd.n150 Vdd.n149 4.5005
R628 Vdd.n181 Vdd.n180 4.5005
R629 Vdd.n176 Vdd.n175 4.5005
R630 Vdd.n170 Vdd.n158 4.5005
R631 Vdd.n169 Vdd.n168 4.5005
R632 Vdd.n167 Vdd.n166 4.5005
R633 Vdd.n172 Vdd.n171 4.5005
R634 Vdd.n202 Vdd.n201 4.5005
R635 Vdd.n186 Vdd.n185 4.5005
R636 Vdd.n193 Vdd.n190 4.5005
R637 Vdd.n195 Vdd.n194 4.5005
R638 Vdd.n82 Vdd.n65 4.5005
R639 Vdd.n58 Vdd.n57 4.5005
R640 Vdd.n89 Vdd.n88 4.5005
R641 Vdd.n84 Vdd.n83 4.5005
R642 Vdd.n78 Vdd.n66 4.5005
R643 Vdd.n77 Vdd.n76 4.5005
R644 Vdd.n75 Vdd.n74 4.5005
R645 Vdd.n80 Vdd.n79 4.5005
R646 Vdd.n46 Vdd.n29 4.5005
R647 Vdd.n22 Vdd.n21 4.5005
R648 Vdd.n53 Vdd.n52 4.5005
R649 Vdd.n48 Vdd.n47 4.5005
R650 Vdd.n42 Vdd.n30 4.5005
R651 Vdd.n41 Vdd.n40 4.5005
R652 Vdd.n39 Vdd.n38 4.5005
R653 Vdd.n44 Vdd.n43 4.5005
R654 Vdd.n18 Vdd.n17 4.5005
R655 Vdd.n2 Vdd.n1 4.5005
R656 Vdd.n9 Vdd.n6 4.5005
R657 Vdd.n11 Vdd.n10 4.5005
R658 Vdd.n105 Vdd.n104 3.31679
R659 Vdd.n105 Vdd.n96 3.31679
R660 Vdd.n108 Vdd.n95 3.31679
R661 Vdd.n97 Vdd.n95 3.31679
R662 Vdd.n126 Vdd.n123 3.31679
R663 Vdd.n128 Vdd.n125 3.31679
R664 Vdd.n129 Vdd.n128 3.31679
R665 Vdd.n126 Vdd.n124 3.31679
R666 Vdd.n118 Vdd.n115 3.31679
R667 Vdd.n120 Vdd.n118 3.31679
R668 Vdd.n162 Vdd.n159 3.31679
R669 Vdd.n164 Vdd.n161 3.31679
R670 Vdd.n165 Vdd.n164 3.31679
R671 Vdd.n162 Vdd.n160 3.31679
R672 Vdd.n154 Vdd.n151 3.31679
R673 Vdd.n156 Vdd.n154 3.31679
R674 Vdd.n191 Vdd.n189 3.31679
R675 Vdd.n192 Vdd.n191 3.31679
R676 Vdd.n199 Vdd.n198 3.31679
R677 Vdd.n200 Vdd.n199 3.31679
R678 Vdd.n70 Vdd.n67 3.31679
R679 Vdd.n72 Vdd.n69 3.31679
R680 Vdd.n73 Vdd.n72 3.31679
R681 Vdd.n70 Vdd.n68 3.31679
R682 Vdd.n62 Vdd.n59 3.31679
R683 Vdd.n64 Vdd.n62 3.31679
R684 Vdd.n34 Vdd.n31 3.31679
R685 Vdd.n36 Vdd.n33 3.31679
R686 Vdd.n37 Vdd.n36 3.31679
R687 Vdd.n34 Vdd.n32 3.31679
R688 Vdd.n26 Vdd.n23 3.31679
R689 Vdd.n28 Vdd.n26 3.31679
R690 Vdd.n7 Vdd.n5 3.31679
R691 Vdd.n8 Vdd.n7 3.31679
R692 Vdd.n15 Vdd.n14 3.31679
R693 Vdd.n16 Vdd.n15 3.31679
R694 Vdd.n128 Vdd.n127 1.49311
R695 Vdd.n127 Vdd.n126 1.49311
R696 Vdd.n142 Vdd.n118 1.49311
R697 Vdd.n164 Vdd.n163 1.49311
R698 Vdd.n163 Vdd.n162 1.49311
R699 Vdd.n178 Vdd.n154 1.49311
R700 Vdd.n72 Vdd.n71 1.49311
R701 Vdd.n71 Vdd.n70 1.49311
R702 Vdd.n86 Vdd.n62 1.49311
R703 Vdd.n36 Vdd.n35 1.49311
R704 Vdd.n35 Vdd.n34 1.49311
R705 Vdd.n50 Vdd.n26 1.49311
R706 Vdd.n197 Vdd.n196 0.9005
R707 Vdd.n197 Vdd.n188 0.9005
R708 Vdd.n187 Vdd.n184 0.9005
R709 Vdd.n188 Vdd.n187 0.9005
R710 Vdd.n137 Vdd.n119 0.788
R711 Vdd.n119 Vdd.n117 0.788
R712 Vdd.n116 Vdd.n112 0.788
R713 Vdd.n117 Vdd.n116 0.788
R714 Vdd.n173 Vdd.n155 0.788
R715 Vdd.n155 Vdd.n153 0.788
R716 Vdd.n152 Vdd.n148 0.788
R717 Vdd.n153 Vdd.n152 0.788
R718 Vdd.n81 Vdd.n63 0.788
R719 Vdd.n63 Vdd.n61 0.788
R720 Vdd.n60 Vdd.n56 0.788
R721 Vdd.n61 Vdd.n60 0.788
R722 Vdd.n45 Vdd.n27 0.788
R723 Vdd.n27 Vdd.n25 0.788
R724 Vdd.n24 Vdd.n20 0.788
R725 Vdd.n25 Vdd.n24 0.788
R726 Vdd.n91 Vdd.n55 0.6773
R727 Vdd.n204 Vdd.n183 0.6773
R728 Vdd.n183 Vdd.n147 0.6773
R729 Vdd.n100 Vdd.n98 0.6305
R730 Vdd.n106 Vdd.n98 0.6305
R731 Vdd.n107 Vdd.n92 0.6305
R732 Vdd.n107 Vdd.n106 0.6305
R733 Vdd.n13 Vdd.n12 0.6305
R734 Vdd.n13 Vdd.n4 0.6305
R735 Vdd.n3 Vdd.n0 0.6305
R736 Vdd.n4 Vdd.n3 0.6305
R737 Vdd.n111 Vdd.n92 0.600174
R738 Vdd.n19 Vdd.n0 0.600174
R739 Vdd.n146 Vdd.n112 0.496478
R740 Vdd.n182 Vdd.n148 0.496478
R741 Vdd.n90 Vdd.n56 0.496478
R742 Vdd.n54 Vdd.n20 0.496478
R743 Vdd.n203 Vdd.n184 0.454413
R744 Vdd Vdd.n91 0.4019
R745 Vdd Vdd.n204 0.1571
R746 Vdd.n103 Vdd.n99 0.1445
R747 Vdd.n109 Vdd.n94 0.1445
R748 Vdd.n110 Vdd.n93 0.1445
R749 Vdd.n102 Vdd.n101 0.1445
R750 Vdd.n135 Vdd.n134 0.1445
R751 Vdd.n134 Vdd.n133 0.1445
R752 Vdd.n133 Vdd.n130 0.1445
R753 Vdd.n140 Vdd.n121 0.1445
R754 Vdd.n121 Vdd.n114 0.1445
R755 Vdd.n144 Vdd.n114 0.1445
R756 Vdd.n139 Vdd.n138 0.1445
R757 Vdd.n138 Vdd.n113 0.1445
R758 Vdd.n145 Vdd.n113 0.1445
R759 Vdd.n136 Vdd.n122 0.1445
R760 Vdd.n132 Vdd.n122 0.1445
R761 Vdd.n132 Vdd.n131 0.1445
R762 Vdd.n171 Vdd.n170 0.1445
R763 Vdd.n170 Vdd.n169 0.1445
R764 Vdd.n169 Vdd.n166 0.1445
R765 Vdd.n176 Vdd.n157 0.1445
R766 Vdd.n157 Vdd.n150 0.1445
R767 Vdd.n180 Vdd.n150 0.1445
R768 Vdd.n175 Vdd.n174 0.1445
R769 Vdd.n174 Vdd.n149 0.1445
R770 Vdd.n181 Vdd.n149 0.1445
R771 Vdd.n172 Vdd.n158 0.1445
R772 Vdd.n168 Vdd.n158 0.1445
R773 Vdd.n168 Vdd.n167 0.1445
R774 Vdd.n194 Vdd.n193 0.1445
R775 Vdd.n201 Vdd.n186 0.1445
R776 Vdd.n202 Vdd.n185 0.1445
R777 Vdd.n195 Vdd.n190 0.1445
R778 Vdd.n79 Vdd.n78 0.1445
R779 Vdd.n78 Vdd.n77 0.1445
R780 Vdd.n77 Vdd.n74 0.1445
R781 Vdd.n84 Vdd.n65 0.1445
R782 Vdd.n65 Vdd.n58 0.1445
R783 Vdd.n88 Vdd.n58 0.1445
R784 Vdd.n83 Vdd.n82 0.1445
R785 Vdd.n82 Vdd.n57 0.1445
R786 Vdd.n89 Vdd.n57 0.1445
R787 Vdd.n80 Vdd.n66 0.1445
R788 Vdd.n76 Vdd.n66 0.1445
R789 Vdd.n76 Vdd.n75 0.1445
R790 Vdd.n43 Vdd.n42 0.1445
R791 Vdd.n42 Vdd.n41 0.1445
R792 Vdd.n41 Vdd.n38 0.1445
R793 Vdd.n48 Vdd.n29 0.1445
R794 Vdd.n29 Vdd.n22 0.1445
R795 Vdd.n52 Vdd.n22 0.1445
R796 Vdd.n47 Vdd.n46 0.1445
R797 Vdd.n46 Vdd.n21 0.1445
R798 Vdd.n53 Vdd.n21 0.1445
R799 Vdd.n44 Vdd.n30 0.1445
R800 Vdd.n40 Vdd.n30 0.1445
R801 Vdd.n40 Vdd.n39 0.1445
R802 Vdd.n10 Vdd.n9 0.1445
R803 Vdd.n17 Vdd.n2 0.1445
R804 Vdd.n18 Vdd.n1 0.1445
R805 Vdd.n11 Vdd.n6 0.1445
R806 Vin_neg Vin_neg.n0 5.34237
R807 Vin Vin.n0 5.34231
C0 Iex_1_i xm9_0/a_28_n131# 0.00408f
C1 xm4_0/a_28_n281# Iex_4_i 0.03326f
C2 xm4_0/a_28_n281# Vin_neg 0.0502f
C3 Vdd xm9_0/a_n50_n339# 0.95653f
C4 Vdd Vin 0.00973f
C5 Vdd xm9_0/a_28_n131# 0.31488f
C6 Vin xm9_0/a_n50_n339# 0.00641f
C7 xm9_0/a_n50_n339# xm9_0/a_28_n131# 0.20766f
C8 Vdd xm4_0/a_28_n281# 1.80055f
C9 Vin xm9_0/a_28_n131# 0.00116f
C10 xm9_0/a_n50_n339# xm4_0/a_28_n281# 0.03121f
C11 xm9_0/a_28_n131# xm4_0/a_28_n281# 0.42403f
C12 Iex_2_i xm3_0/a_28_n281# 0.03622f
C13 Iex_3_i Iex_4_i 0.00482f
C14 Iex_3_i Vin_neg 0
C15 Iex_1_i Iex_2_i 0.00482f
C16 Vin_neg Iex_4_i 0
C17 Vdd Iex_2_i 0.01027f
C18 Vdd Iex_3_i 0.01046f
C19 Vin Iex_2_i 0
C20 Vdd xm3_0/a_28_n281# 1.69168f
C21 Iex_3_i xm9_0/a_28_n131# 0.00408f
C22 Vdd Iex_4_i 0.00908f
C23 xm9_0/a_n50_n339# xm3_0/a_28_n281# 0.02036f
C24 Vdd Vin_neg 0.00868f
C25 Vin xm3_0/a_28_n281# 0.00428f
C26 xm9_0/a_n50_n339# Iex_4_i 0.00357f
C27 xm9_0/a_n50_n339# Vin_neg 0.00645f
C28 xm9_0/a_28_n131# xm3_0/a_28_n281# 0.04461f
C29 Iex_3_i xm4_0/a_28_n281# 0.04082f
C30 Vdd Iex_1_i 0.02308f
C31 xm9_0/a_28_n131# Iex_4_i 0.00408f
C32 xm9_0/a_28_n131# Vin_neg 0.04273f
C33 Iex_1_i xm9_0/a_n50_n339# 0.00645f
C34 Vin.n0 Vss 0.00994f
C35 Vin_neg.n0 Vss 0.04893f
C36 Vdd.n0 Vss 0.00994f
C37 Vdd.n1 Vss 0.00533f
C38 Vdd.n2 Vss 0.00148f
C39 Vdd.n3 Vss 0.00717f
C40 Vdd.n4 Vss 0.06245f
C41 Vdd.n5 Vss 0.00435f
C42 Vdd.n6 Vss 0.00486f
C43 Vdd.n7 Vss 0.04034f
C44 Vdd.n8 Vss 0.00435f
C45 Vdd.n9 Vss 0.00148f
C46 Vdd.n10 Vss 0.00148f
C47 Vdd.n11 Vss 0.00486f
C48 Vdd.n12 Vss 0.02243f
C49 Vdd.n13 Vss 0.00717f
C50 Vdd.n14 Vss 0.00435f
C51 Vdd.n15 Vss 0.04034f
C52 Vdd.n16 Vss 0.00435f
C53 Vdd.n17 Vss 0.00148f
C54 Vdd.n18 Vss 0.00442f
C55 Vdd.n19 Vss 0.01544f
C56 Vdd.n20 Vss 0.00838f
C57 Vdd.n21 Vss 0.00182f
C58 Vdd.n22 Vss 0.00182f
C59 Vdd.n23 Vss 0.00131f
C60 Vdd.n24 Vss 0.00605f
C61 Vdd.n25 Vss 0.06645f
C62 Vdd.n27 Vss 0.00605f
C63 Vdd.n28 Vss 0.00131f
C64 Vdd.n29 Vss 0.00182f
C65 Vdd.n30 Vss 0.00182f
C66 Vdd.n31 Vss 0.00378f
C67 Vdd.n32 Vss 0.00131f
C68 Vdd.n33 Vss 0.00131f
C69 Vdd.n35 Vss 0.04519f
C70 Vdd.n37 Vss 0.00378f
C71 Vdd.n38 Vss 0.00148f
C72 Vdd.n39 Vss 0.0044f
C73 Vdd.n40 Vss 0.00182f
C74 Vdd.n41 Vss 0.00182f
C75 Vdd.n42 Vss 0.00182f
C76 Vdd.n43 Vss 0.00148f
C77 Vdd.n44 Vss 0.0044f
C78 Vdd.n45 Vss 0.01935f
C79 Vdd.n46 Vss 0.00182f
C80 Vdd.n47 Vss 0.00465f
C81 Vdd.n48 Vss 0.00148f
C82 Vdd.n49 Vss 0.00378f
C83 Vdd.n50 Vss 0.04519f
C84 Vdd.n51 Vss 0.00378f
C85 Vdd.n52 Vss 0.00148f
C86 Vdd.n53 Vss 0.00407f
C87 Vdd.n54 Vss 0.01163f
C88 Vdd.n55 Vss 0.07467f
C89 Vdd.n56 Vss 0.00838f
C90 Vdd.n57 Vss 0.00182f
C91 Vdd.n58 Vss 0.00182f
C92 Vdd.n59 Vss 0.00131f
C93 Vdd.n60 Vss 0.00605f
C94 Vdd.n61 Vss 0.06645f
C95 Vdd.n63 Vss 0.00605f
C96 Vdd.n64 Vss 0.00131f
C97 Vdd.n65 Vss 0.00182f
C98 Vdd.n66 Vss 0.00182f
C99 Vdd.n67 Vss 0.00378f
C100 Vdd.n68 Vss 0.00131f
C101 Vdd.n69 Vss 0.00131f
C102 Vdd.n71 Vss 0.04519f
C103 Vdd.n73 Vss 0.00378f
C104 Vdd.n74 Vss 0.00148f
C105 Vdd.n75 Vss 0.0044f
C106 Vdd.n76 Vss 0.00182f
C107 Vdd.n77 Vss 0.00182f
C108 Vdd.n78 Vss 0.00182f
C109 Vdd.n79 Vss 0.00148f
C110 Vdd.n80 Vss 0.0044f
C111 Vdd.n81 Vss 0.01935f
C112 Vdd.n82 Vss 0.00182f
C113 Vdd.n83 Vss 0.00465f
C114 Vdd.n84 Vss 0.00148f
C115 Vdd.n85 Vss 0.00378f
C116 Vdd.n86 Vss 0.04519f
C117 Vdd.n87 Vss 0.00378f
C118 Vdd.n88 Vss 0.00148f
C119 Vdd.n89 Vss 0.00407f
C120 Vdd.n90 Vss 0.01163f
C121 Vdd.n91 Vss 0.02801f
C122 Vdd.n92 Vss 0.00994f
C123 Vdd.n93 Vss 0.00533f
C124 Vdd.n94 Vss 0.00148f
C125 Vdd.n95 Vss 0.04034f
C126 Vdd.n96 Vss 0.00435f
C127 Vdd.n97 Vss 0.00435f
C128 Vdd.n98 Vss 0.00717f
C129 Vdd.n99 Vss 0.00148f
C130 Vdd.n100 Vss 0.02243f
C131 Vdd.n101 Vss 0.00486f
C132 Vdd.n102 Vss 0.00486f
C133 Vdd.n103 Vss 0.00148f
C134 Vdd.n104 Vss 0.00435f
C135 Vdd.n105 Vss 0.04034f
C136 Vdd.n106 Vss 0.06245f
C137 Vdd.n107 Vss 0.00717f
C138 Vdd.n108 Vss 0.00435f
C139 Vdd.n109 Vss 0.00148f
C140 Vdd.n110 Vss 0.00442f
C141 Vdd.n111 Vss 0.01281f
C142 Vdd.n112 Vss 0.00838f
C143 Vdd.n113 Vss 0.00182f
C144 Vdd.n114 Vss 0.00182f
C145 Vdd.n115 Vss 0.00131f
C146 Vdd.n116 Vss 0.00605f
C147 Vdd.n117 Vss 0.06645f
C148 Vdd.n119 Vss 0.00605f
C149 Vdd.n120 Vss 0.00131f
C150 Vdd.n121 Vss 0.00182f
C151 Vdd.n122 Vss 0.00182f
C152 Vdd.n123 Vss 0.00378f
C153 Vdd.n124 Vss 0.00131f
C154 Vdd.n125 Vss 0.00131f
C155 Vdd.n127 Vss 0.04519f
C156 Vdd.n129 Vss 0.00378f
C157 Vdd.n130 Vss 0.00148f
C158 Vdd.n131 Vss 0.0044f
C159 Vdd.n132 Vss 0.00182f
C160 Vdd.n133 Vss 0.00182f
C161 Vdd.n134 Vss 0.00182f
C162 Vdd.n135 Vss 0.00148f
C163 Vdd.n136 Vss 0.0044f
C164 Vdd.n137 Vss 0.01935f
C165 Vdd.n138 Vss 0.00182f
C166 Vdd.n139 Vss 0.00465f
C167 Vdd.n140 Vss 0.00148f
C168 Vdd.n141 Vss 0.00378f
C169 Vdd.n142 Vss 0.04519f
C170 Vdd.n143 Vss 0.00378f
C171 Vdd.n144 Vss 0.00148f
C172 Vdd.n145 Vss 0.00407f
C173 Vdd.n146 Vss 0.01163f
C174 Vdd.n147 Vss 0.05547f
C175 Vdd.n148 Vss 0.00838f
C176 Vdd.n149 Vss 0.00182f
C177 Vdd.n150 Vss 0.00182f
C178 Vdd.n151 Vss 0.00131f
C179 Vdd.n152 Vss 0.00605f
C180 Vdd.n153 Vss 0.06645f
C181 Vdd.n155 Vss 0.00605f
C182 Vdd.n156 Vss 0.00131f
C183 Vdd.n157 Vss 0.00182f
C184 Vdd.n158 Vss 0.00182f
C185 Vdd.n159 Vss 0.00378f
C186 Vdd.n160 Vss 0.00131f
C187 Vdd.n161 Vss 0.00131f
C188 Vdd.n163 Vss 0.04519f
C189 Vdd.n165 Vss 0.00378f
C190 Vdd.n166 Vss 0.00148f
C191 Vdd.n167 Vss 0.0044f
C192 Vdd.n168 Vss 0.00182f
C193 Vdd.n169 Vss 0.00182f
C194 Vdd.n170 Vss 0.00182f
C195 Vdd.n171 Vss 0.00148f
C196 Vdd.n172 Vss 0.0044f
C197 Vdd.n173 Vss 0.01935f
C198 Vdd.n174 Vss 0.00182f
C199 Vdd.n175 Vss 0.00465f
C200 Vdd.n176 Vss 0.00148f
C201 Vdd.n177 Vss 0.00378f
C202 Vdd.n178 Vss 0.04519f
C203 Vdd.n179 Vss 0.00378f
C204 Vdd.n180 Vss 0.00148f
C205 Vdd.n181 Vss 0.00407f
C206 Vdd.n182 Vss 0.01163f
C207 Vdd.n183 Vss 0.03497f
C208 Vdd.n184 Vss 0.00777f
C209 Vdd.n185 Vss 0.00486f
C210 Vdd.n186 Vss 0.00148f
C211 Vdd.n187 Vss 0.00599f
C212 Vdd.n188 Vss 0.04742f
C213 Vdd.n189 Vss 0.00372f
C214 Vdd.n190 Vss 0.0047f
C215 Vdd.n191 Vss 0.03281f
C216 Vdd.n192 Vss 0.00372f
C217 Vdd.n193 Vss 0.00148f
C218 Vdd.n194 Vss 0.00148f
C219 Vdd.n195 Vss 0.0047f
C220 Vdd.n196 Vss 0.01757f
C221 Vdd.n197 Vss 0.00599f
C222 Vdd.n198 Vss 0.00372f
C223 Vdd.n199 Vss 0.03281f
C224 Vdd.n200 Vss 0.00372f
C225 Vdd.n201 Vss 0.00148f
C226 Vdd.n202 Vss 0.00442f
C227 Vdd.n203 Vss 0.01219f
C228 Vdd.n204 Vss 0.02197f
C229 Vss.n0 Vss 0.00586f
C230 Vss.n1 Vss 0.03112f
C231 Vss.n2 Vss 0.00278f
C232 Vss.n3 Vss 0.00168f
C233 Vss.n4 Vss 0
C234 Vss.n5 Vss 0.00133f
C235 Vss.n6 Vss 0.00215f
C236 Vss.n7 Vss 0.01961f
C237 Vss.n8 Vss 0.00133f
C238 Vss.n9 Vss 0.00133f
C239 Vss.n10 Vss 0.00168f
C240 Vss.n11 Vss 0
C241 Vss.n12 Vss 0
C242 Vss.n13 Vss 0.00174f
C243 Vss.n14 Vss 0.0063f
C244 Vss.n15 Vss 0.00215f
C245 Vss.n16 Vss 0.01907f
C246 Vss.n17 Vss 0.03291f
C247 Vss.n18 Vss 0.0161f
C248 Vss.n19 Vss 0.01879f
C249 Vss.n20 Vss 0.00131f
C250 Vss.n21 Vss 0.00131f
C251 Vss.n22 Vss 0.00161f
C252 Vss.n23 Vss 0
C253 Vss.n24 Vss 0
C254 Vss.n25 Vss 0
C255 Vss.n26 Vss 0
C256 Vss.n27 Vss 0
C257 Vss.n28 Vss 0
C258 Vss.n29 Vss 0
C259 Vss.n30 Vss 0
C260 Vss.n31 Vss 0
C261 Vss.n32 Vss 0
C262 Vss.n33 Vss 0
C263 Vss.n34 Vss 0
C264 Vss.n35 Vss 0
C265 Vss.n36 Vss 0
C266 Vss.n37 Vss 0.00151f
C267 Vss.n38 Vss 0
C268 Vss.n39 Vss 0.00209f
C269 Vss.n40 Vss 0.01453f
C270 Vss.n41 Vss 0.02951f
C271 Vss.n42 Vss 0
C272 Vss.n43 Vss 0
C273 Vss.n44 Vss 0
C274 Vss.n45 Vss 0
C275 Vss.n46 Vss 0
C276 Vss.n47 Vss 0.00971f
C277 Vss.n48 Vss 0
C278 Vss.n49 Vss 0
C279 Vss.n50 Vss 0
C280 Vss.n51 Vss 0
C281 Vss.n52 Vss 0
C282 Vss.n53 Vss 0.01453f
C283 Vss.n54 Vss 0
C284 Vss.n55 Vss 0
C285 Vss.n56 Vss 0
C286 Vss.n57 Vss 0
C287 Vss.n58 Vss 0
C288 Vss.n59 Vss 0
C289 Vss.n60 Vss 0
C290 Vss.n61 Vss 0
C291 Vss.n62 Vss 0
C292 Vss.n63 Vss 0.01453f
C293 Vss.n64 Vss 0.01453f
C294 Vss.n65 Vss 0
C295 Vss.n66 Vss 0.01453f
C296 Vss.n67 Vss 0
C297 Vss.n68 Vss 0
C298 Vss.n69 Vss 0
C299 Vss.n70 Vss 0
C300 Vss.n71 Vss 0
C301 Vss.n72 Vss 0
C302 Vss.n73 Vss 0
C303 Vss.n74 Vss 0.01453f
C304 Vss.n75 Vss 0.01453f
C305 Vss.n76 Vss 0
C306 Vss.n77 Vss 0.01207f
C307 Vss.n78 Vss 0
C308 Vss.n79 Vss 0
C309 Vss.n80 Vss 0
C310 Vss.n81 Vss 0
C311 Vss.n82 Vss 0
C312 Vss.n83 Vss 0
C313 Vss.n84 Vss 0
C314 Vss.n85 Vss 0.01453f
C315 Vss.n86 Vss 0.01453f
C316 Vss.n87 Vss 0
C317 Vss.n88 Vss 0.01453f
C318 Vss.n89 Vss 0
C319 Vss.n90 Vss 0
C320 Vss.n91 Vss 0
C321 Vss.n92 Vss 0
C322 Vss.n93 Vss 0.00278f
C323 Vss.n94 Vss 0.00161f
C324 Vss.n95 Vss 0
C325 Vss.n96 Vss 0.00131f
C326 Vss.n97 Vss 0.01879f
C327 Vss.n98 Vss 0.00131f
C328 Vss.n99 Vss 0
C329 Vss.n100 Vss 0
C330 Vss.n101 Vss 0
C331 Vss.n102 Vss 0
C332 Vss.n103 Vss 0
C333 Vss.n104 Vss 0
C334 Vss.n105 Vss 0
C335 Vss.n106 Vss 0
C336 Vss.n107 Vss 0
C337 Vss.n108 Vss 0
C338 Vss.n109 Vss 0
C339 Vss.n110 Vss 0
C340 Vss.n111 Vss 0
C341 Vss.n112 Vss 0
C342 Vss.n113 Vss 0
C343 Vss.n114 Vss 0
C344 Vss.n115 Vss 0
C345 Vss.n116 Vss 0
C346 Vss.n117 Vss 0
C347 Vss.n118 Vss 0
C348 Vss.n119 Vss 0.00161f
C349 Vss.n120 Vss 0.00382f
C350 Vss.n121 Vss 0.00209f
C351 Vss.n122 Vss 0.20947f
C352 Vss.n123 Vss 0.1293f
C353 Vss.n124 Vss 0.06797f
C354 Vss.n125 Vss 0.06797f
C355 Vss.n126 Vss 0.01961f
C356 Vss.n127 Vss 0.00133f
C357 Vss.n128 Vss 0.00133f
C358 Vss.n129 Vss 0.00174f
C359 Vss.n130 Vss 0.00158f
C360 Vss.n131 Vss 0.00215f
C361 Vss.n132 Vss 0
C362 Vss.n133 Vss 0.00274f
C363 Vss.n134 Vss 0.00278f
C364 Vss.n135 Vss 0.00168f
C365 Vss.n136 Vss 0
C366 Vss.n137 Vss 0.00133f
C367 Vss.n138 Vss 0.02037f
C368 Vss.n139 Vss 0.00131f
C369 Vss.n140 Vss 0.00131f
C370 Vss.n141 Vss 0.00161f
C371 Vss.n142 Vss 0
C372 Vss.n143 Vss 0
C373 Vss.n144 Vss 0
C374 Vss.n145 Vss 0
C375 Vss.n146 Vss 0
C376 Vss.n147 Vss 0.01389f
C377 Vss.n148 Vss 0.01453f
C378 Vss.n149 Vss 0.01453f
C379 Vss.n150 Vss 0
C380 Vss.n151 Vss 0
C381 Vss.n152 Vss 0
C382 Vss.n153 Vss 0
C383 Vss.n154 Vss 0
C384 Vss.n155 Vss 0
C385 Vss.n156 Vss 0
C386 Vss.n157 Vss 0
C387 Vss.n158 Vss 0
C388 Vss.n159 Vss 0
C389 Vss.n160 Vss 0
C390 Vss.n161 Vss 0
C391 Vss.n162 Vss 0
C392 Vss.n163 Vss 0.01453f
C393 Vss.n164 Vss 0
C394 Vss.n165 Vss 0
C395 Vss.n166 Vss 0
C396 Vss.n167 Vss 0
C397 Vss.n168 Vss 0
C398 Vss.n169 Vss 0
C399 Vss.n170 Vss 0
C400 Vss.n171 Vss 0
C401 Vss.n172 Vss 0.07061f
C402 Vss.n173 Vss 0.09057f
C403 Vss.n174 Vss 0
C404 Vss.n175 Vss 0
C405 Vss.n176 Vss 0.01453f
C406 Vss.n177 Vss 0
C407 Vss.n178 Vss 0
C408 Vss.n179 Vss 0
C409 Vss.n180 Vss 0
C410 Vss.n181 Vss 0
C411 Vss.n182 Vss 0
C412 Vss.n183 Vss 0.00131f
C413 Vss.n184 Vss 0
C414 Vss.n185 Vss 0.00131f
C415 Vss.n186 Vss 0.00161f
C416 Vss.n187 Vss 0
C417 Vss.n188 Vss 0
C418 Vss.n189 Vss 0
C419 Vss.n190 Vss 0
C420 Vss.n191 Vss 0
C421 Vss.n192 Vss 0
C422 Vss.n193 Vss 0
C423 Vss.n194 Vss 0
C424 Vss.n195 Vss 0
C425 Vss.n196 Vss 0
C426 Vss.n197 Vss 0
C427 Vss.n198 Vss 0
C428 Vss.n199 Vss 0
C429 Vss.n200 Vss 0
C430 Vss.n201 Vss 0
C431 Vss.n202 Vss 0
C432 Vss.n203 Vss 0
C433 Vss.n204 Vss 0
C434 Vss.n205 Vss 0
C435 Vss.n206 Vss 0
C436 Vss.n207 Vss 0
C437 Vss.n208 Vss 0
C438 Vss.n209 Vss 0.00151f
C439 Vss.n210 Vss 0.00644f
C440 Vss.n211 Vss 0.00278f
C441 Vss.n212 Vss 0.00209f
C442 Vss.n213 Vss 0.07796f
C443 Vss.n214 Vss 0.01879f
C444 Vss.n215 Vss 0.01453f
C445 Vss.n216 Vss 0
C446 Vss.n217 Vss 0
C447 Vss.n218 Vss 0
C448 Vss.n219 Vss 0
C449 Vss.n220 Vss 0
C450 Vss.n221 Vss 0.01453f
C451 Vss.n222 Vss 0.01099f
C452 Vss.n223 Vss 0.0161f
C453 Vss.n224 Vss 0.0108f
C454 Vss.n225 Vss 0
C455 Vss.n226 Vss 0
C456 Vss.n227 Vss 0
C457 Vss.n228 Vss 0
C458 Vss.n229 Vss 0
C459 Vss.n230 Vss 0.01453f
C460 Vss.n231 Vss 0.01453f
C461 Vss.n232 Vss 0.01453f
C462 Vss.n233 Vss 0
C463 Vss.n234 Vss 0
C464 Vss.n235 Vss 0
C465 Vss.n236 Vss 0
C466 Vss.n237 Vss 0
C467 Vss.n238 Vss 0.01453f
C468 Vss.n239 Vss 0
C469 Vss.n240 Vss 0
C470 Vss.n241 Vss 0
C471 Vss.n242 Vss 0
C472 Vss.n243 Vss 0.00161f
C473 Vss.n244 Vss 0.00382f
C474 Vss.n245 Vss 0.00209f
C475 Vss.n246 Vss 0.0296f
C476 Vss.n247 Vss 0.03704f
C477 Vss.n248 Vss 0.01961f
C478 Vss.n249 Vss 0.00133f
C479 Vss.n250 Vss 0
C480 Vss.n251 Vss 0
C481 Vss.n252 Vss 0.00168f
C482 Vss.n253 Vss 0.0063f
C483 Vss.n254 Vss 0.00215f
C484 Vss.n255 Vss 0.01907f
C485 Vss.n256 Vss 0.03291f
C486 Vss.n257 Vss 0.03032f
C487 Vss.n258 Vss 0.01961f
C488 Vss.n259 Vss 0.00133f
C489 Vss.n260 Vss 0
C490 Vss.n261 Vss 0.00158f
C491 Vss.n262 Vss 0.00274f
C492 Vss.n263 Vss 0.00609f
C493 Iex_1_i Vss -0.05753f
C494 Iex_3_i Vss -0.04057f
C495 Vin Vss -0.04735f
C496 xm9_0/a_n50_n339# Vss -0.72525f
C497 xm4_0/a_28_n281# Vss -1.91373f
C498 Vin_neg Vss 0.06542f
C499 Iex_2_i Vss -0.04945f
C500 xm9_0/a_28_n131# Vss -0.51199f
C501 Iex_4_i Vss -0.04509f
C502 xm3_0/a_28_n281# Vss -1.41331f
C503 Vdd Vss -13.92535f
.ends
