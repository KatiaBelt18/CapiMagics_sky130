** sch_path: /foss/designs/CapiMagics/sch/encoder/encoder.sch
.subckt encoder Vdd Vss Vin Vin_neg Iex_1_i Iex_2_i Iex_3_i Iex_4_i
*.PININFO Vdd:B Vss:B Vin:I Vin_neg:I Iex_1_i:O Iex_4_i:O Iex_2_i:O Iex_3_i:O
xm1 x Vin a Vss nfet_03v3 L=10u W=0.5u nf=1 m=1
xm2 y Vin_neg a Vss nfet_03v3 L=10u W=0.5u nf=1 m=1
xm3 x x Vdd Vdd pfet_03v3 L=0.28u W=2u nf=1 m=1
xm4 y y Vdd Vdd pfet_03v3 L=0.28u W=2u nf=1 m=1
xm5 Iex_2_i x Vdd Vdd pfet_03v3 L=1.86u W=0.93u nf=1 m=1
xm7 Iex_3_i y Vdd Vdd pfet_03v3 L=1.86u W=0.93u nf=1 m=1
xm9 a net1 Vss Vss nfet_03v3 L=0.28u W=0.5u nf=1 m=1
xm10 net1 net1 Vss Vss nfet_03v3 L=0.28u W=0.5u nf=1 m=1
xm11 net1 net1 Vdd Vdd pfet_03v3 L=0.28u W=0.5u nf=1 m=1
xm6 Iex_4_i y Vdd Vdd pfet_03v3 L=1.86u W=0.93u nf=1 m=1
xm8 Iex_1_i x Vdd Vdd pfet_03v3 L=1.86u W=0.93u nf=1 m=1
.ends
