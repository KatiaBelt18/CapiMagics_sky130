* NGSPICE file created from encoder.ext - technology: gf180mcuD

.subckt xm5 a_n306_n173# a_186_n173# w_n572_n603# a_n186_n382# VSUBS
X0 a_186_n173# a_n186_n382# a_n306_n173# w_n572_n603# pfet_03v3 ad=0.558p pd=3.06u as=0.558p ps=3.06u w=0.93u l=1.86u
C0 a_n306_n173# a_n186_n382# 0.11626f
C1 w_n572_n603# a_186_n173# 0.66931f
C2 a_n186_n382# a_186_n173# 0.05372f
C3 w_n572_n603# a_n186_n382# 0.94238f
C4 a_n306_n173# a_186_n173# 0.38397f
C5 a_n306_n173# w_n572_n603# 0.29685f
C6 a_186_n173# VSUBS 0.04839f
C7 a_n306_n173# VSUBS 0.04832f
C8 a_n186_n382# VSUBS 0.07458f
C9 w_n572_n603# VSUBS 5.08511f
.ends

.subckt xm3 a_28_n281# a_n178_n281# w_n444_n709# a_n50_n489# VSUBS
X0 a_28_n281# a_n50_n489# a_n178_n281# w_n444_n709# pfet_03v3 ad=1.5p pd=5.5u as=1.5p ps=5.5u w=2u l=0.28u
C0 a_n178_n281# a_n50_n489# 0.0391f
C1 w_n444_n709# a_28_n281# 0.6139f
C2 a_n50_n489# a_28_n281# 0.02705f
C3 w_n444_n709# a_n50_n489# 0.38939f
C4 a_n178_n281# a_28_n281# 0.53377f
C5 a_n178_n281# w_n444_n709# 0.35562f
C6 a_28_n281# VSUBS 0.08168f
C7 a_n178_n281# VSUBS 0.08054f
C8 a_n50_n489# VSUBS 0.0484f
C9 w_n444_n709# VSUBS 4.62248f
.ends

.subckt xm11 a_n178_n131# a_n50_n339# w_n444_n560# a_28_n131# VSUBS
X0 a_28_n131# a_n50_n339# a_n178_n131# w_n444_n560# pfet_03v3 ad=0.375p pd=2.5u as=0.375p ps=2.5u w=0.5u l=0.28u
C0 a_n178_n131# a_n50_n339# 0.02611f
C1 w_n444_n560# a_28_n131# 0.48499f
C2 a_n50_n339# a_28_n131# 0.01004f
C3 w_n444_n560# a_n50_n339# 0.39308f
C4 a_n178_n131# a_28_n131# 0.34063f
C5 a_n178_n131# w_n444_n560# 0.22952f
C6 a_28_n131# VSUBS 0.04441f
C7 a_n178_n131# VSUBS 0.04328f
C8 a_n50_n339# VSUBS 0.04859f
C9 w_n444_n560# VSUBS 3.73985f
.ends

.subckt xm1 a_n1120_n131# a_n1330_n504# a_1000_n131# a_n1000_n339#
X0 a_1000_n131# a_n1000_n339# a_n1120_n131# a_n1330_n504# nfet_03v3 ad=0.3p pd=2.2u as=0.3p ps=2.2u w=0.5u l=10u
C0 a_1000_n131# a_n1120_n131# 1.01551f
C1 a_n1000_n339# a_n1120_n131# 0.42273f
C2 a_1000_n131# a_n1000_n339# 0.06176f
C3 a_1000_n131# a_n1330_n504# 1.43795f
C4 a_n1120_n131# a_n1330_n504# 0.4423f
C5 a_n1000_n339# a_n1330_n504# 4.53847f
.ends

.subckt xm8 a_n306_n173# a_186_n173# w_n572_n603# a_n186_n382# VSUBS
X0 a_186_n173# a_n186_n382# a_n306_n173# w_n572_n603# pfet_03v3 ad=0.558p pd=3.06u as=0.558p ps=3.06u w=0.93u l=1.86u
C0 a_n306_n173# a_n186_n382# 0.11626f
C1 w_n572_n603# a_186_n173# 0.66931f
C2 a_n186_n382# a_186_n173# 0.05372f
C3 w_n572_n603# a_n186_n382# 0.94238f
C4 a_n306_n173# a_186_n173# 0.38397f
C5 a_n306_n173# w_n572_n603# 0.29685f
C6 a_186_n173# VSUBS 0.04839f
C7 a_n306_n173# VSUBS 0.04832f
C8 a_n186_n382# VSUBS 0.07458f
C9 w_n572_n603# VSUBS 5.08511f
.ends

.subckt xm6 a_n306_n173# a_186_n173# w_n572_n603# a_n186_n382# VSUBS
X0 a_186_n173# a_n186_n382# a_n306_n173# w_n572_n603# pfet_03v3 ad=0.558p pd=3.06u as=0.558p ps=3.06u w=0.93u l=1.86u
C0 a_n306_n173# a_n186_n382# 0.11626f
C1 w_n572_n603# a_186_n173# 0.66931f
C2 a_n186_n382# a_186_n173# 0.05372f
C3 w_n572_n603# a_n186_n382# 0.94238f
C4 a_n306_n173# a_186_n173# 0.38397f
C5 a_n306_n173# w_n572_n603# 0.29685f
C6 a_186_n173# VSUBS 0.04839f
C7 a_n306_n173# VSUBS 0.04832f
C8 a_n186_n382# VSUBS 0.07458f
C9 w_n572_n603# VSUBS 5.08511f
.ends

.subckt xm4 a_28_n281# a_n178_n281# w_n444_n709# a_n50_n489# VSUBS
X0 a_28_n281# a_n50_n489# a_n178_n281# w_n444_n709# pfet_03v3 ad=1.5p pd=5.5u as=1.5p ps=5.5u w=2u l=0.28u
C0 a_n178_n281# a_n50_n489# 0.0391f
C1 w_n444_n709# a_28_n281# 0.6139f
C2 a_n50_n489# a_28_n281# 0.02705f
C3 w_n444_n709# a_n50_n489# 0.38939f
C4 a_n178_n281# a_28_n281# 0.53377f
C5 a_n178_n281# w_n444_n709# 0.35562f
C6 a_28_n281# VSUBS 0.08168f
C7 a_n178_n281# VSUBS 0.08054f
C8 a_n50_n489# VSUBS 0.0484f
C9 w_n444_n709# VSUBS 4.62248f
.ends

.subckt xm2 a_n1120_n131# a_n1330_n504# a_1000_n131# a_n1000_n339#
X0 a_1000_n131# a_n1000_n339# a_n1120_n131# a_n1330_n504# nfet_03v3 ad=0.3p pd=2.2u as=0.3p ps=2.2u w=0.5u l=10u
C0 a_1000_n131# a_n1120_n131# 1.01551f
C1 a_n1000_n339# a_n1120_n131# 0.42273f
C2 a_1000_n131# a_n1000_n339# 0.06176f
C3 a_1000_n131# a_n1330_n504# 1.43795f
C4 a_n1120_n131# a_n1330_n504# 0.4423f
C5 a_n1000_n339# a_n1330_n504# 4.53847f
.ends

.subckt xm10 a_n178_n131# a_n50_n339# a_n388_n504# a_28_n131#
X0 a_28_n131# a_n50_n339# a_n178_n131# a_n388_n504# nfet_03v3 ad=0.375p pd=2.5u as=0.375p ps=2.5u w=0.5u l=0.28u
C0 a_28_n131# a_n178_n131# 0.34063f
C1 a_n50_n339# a_n178_n131# 0.02611f
C2 a_28_n131# a_n50_n339# 0.01004f
C3 a_28_n131# a_n388_n504# 0.52938f
C4 a_n178_n131# a_n388_n504# 0.27279f
C5 a_n50_n339# a_n388_n504# 0.44167f
.ends

.subckt xm9 a_n178_n131# a_n50_n339# a_n388_n504# a_28_n131#
X0 a_28_n131# a_n50_n339# a_n178_n131# a_n388_n504# nfet_03v3 ad=0.375p pd=2.5u as=0.375p ps=2.5u w=0.5u l=0.28u
C0 a_28_n131# a_n178_n131# 0.34063f
C1 a_n50_n339# a_n178_n131# 0.02611f
C2 a_28_n131# a_n50_n339# 0.01004f
C3 a_28_n131# a_n388_n504# 0.52938f
C4 a_n178_n131# a_n388_n504# 0.27279f
C5 a_n50_n339# a_n388_n504# 0.44167f
.ends

.subckt xm7 a_n306_n173# a_186_n173# w_n572_n603# a_n186_n382# VSUBS
X0 a_186_n173# a_n186_n382# a_n306_n173# w_n572_n603# pfet_03v3 ad=0.558p pd=3.06u as=0.558p ps=3.06u w=0.93u l=1.86u
C0 a_n306_n173# a_n186_n382# 0.11626f
C1 w_n572_n603# a_186_n173# 0.66931f
C2 a_n186_n382# a_186_n173# 0.05372f
C3 w_n572_n603# a_n186_n382# 0.94238f
C4 a_n306_n173# a_186_n173# 0.38397f
C5 a_n306_n173# w_n572_n603# 0.29685f
C6 a_186_n173# VSUBS 0.04839f
C7 a_n306_n173# VSUBS 0.04832f
C8 a_n186_n382# VSUBS 0.07458f
C9 w_n572_n603# VSUBS 5.08511f
.ends

.subckt encoder vss vdd Vin Vin_neg Iex_1_i Iex_2_i Iex_3_i Iex_4_i
Xxm5_0 vdd Iex_2_i vdd xm3_0/a_28_n281# vss xm5
Xxm3_0 xm3_0/a_28_n281# vdd vdd xm3_0/a_28_n281# vss xm3
Xxm11_0 vdd xm9_0/a_n50_n339# vdd xm9_0/a_n50_n339# vss xm11
Xxm1_0 xm9_0/a_28_n131# vss xm3_0/a_28_n281# Vin xm1
Xxm8_0 vdd Iex_1_i vdd xm3_0/a_28_n281# vss xm8
Xxm6_0 vdd Iex_4_i vdd xm4_0/a_28_n281# vss xm6
Xxm4_0 xm4_0/a_28_n281# vdd vdd xm4_0/a_28_n281# vss xm4
Xxm2_0 xm9_0/a_28_n131# vss xm4_0/a_28_n281# Vin_neg xm2
Xxm10_0 vss xm9_0/a_n50_n339# vss xm9_0/a_n50_n339# xm10
Xxm9_0 vss xm9_0/a_n50_n339# vss xm9_0/a_28_n131# xm9
Xxm7_0 vdd Iex_3_i vdd xm4_0/a_28_n281# vss xm7
R0 Vin_neg Vin_neg.n0 9.80856
R1 Vin Vin.n0 9.80856
R2 vdd.n94 vdd.n93 696.312
R3 vdd.n93 vdd.n85 696.312
R4 vdd.n13 vdd.n12 696.312
R5 vdd.n12 vdd.n11 696.312
R6 vdd.n175 vdd.n174 528.52
R7 vdd.n174 vdd.n173 528.52
R8 vdd.n123 vdd.n104 446.678
R9 vdd.n106 vdd.n104 446.678
R10 vdd.n155 vdd.n136 446.678
R11 vdd.n138 vdd.n136 446.678
R12 vdd.n42 vdd.n23 446.678
R13 vdd.n25 vdd.n23 446.678
R14 vdd.n74 vdd.n55 446.678
R15 vdd.n57 vdd.n55 446.678
R16 vdd.n92 vdd.n83 74.638
R17 vdd.n92 vdd.n91 74.638
R18 vdd.n86 vdd.n84 74.638
R19 vdd.n95 vdd.n84 74.638
R20 vdd.n14 vdd.n3 74.638
R21 vdd.n10 vdd.n3 74.638
R22 vdd.n5 vdd.n4 74.638
R23 vdd.n4 vdd.n2 74.638
R24 vdd.n111 vdd.n101 62.563
R25 vdd.n112 vdd.n111 62.563
R26 vdd.n121 vdd.n120 62.563
R27 vdd.n122 vdd.n121 62.563
R28 vdd.n143 vdd.n133 62.563
R29 vdd.n144 vdd.n143 62.563
R30 vdd.n153 vdd.n152 62.563
R31 vdd.n154 vdd.n153 62.563
R32 vdd.n30 vdd.n20 62.563
R33 vdd.n31 vdd.n30 62.563
R34 vdd.n40 vdd.n39 62.563
R35 vdd.n41 vdd.n40 62.563
R36 vdd.n62 vdd.n52 62.563
R37 vdd.n63 vdd.n62 62.563
R38 vdd.n72 vdd.n71 62.563
R39 vdd.n73 vdd.n72 62.563
R40 vdd.n176 vdd.n165 61.6005
R41 vdd.n172 vdd.n165 61.6005
R42 vdd.n167 vdd.n166 61.6005
R43 vdd.n166 vdd.n164 61.6005
R44 vdd.n118 vdd.n107 14.0005
R45 vdd.n122 vdd.n103 14.0005
R46 vdd.n125 vdd.n101 14.0005
R47 vdd.n150 vdd.n139 14.0005
R48 vdd.n154 vdd.n135 14.0005
R49 vdd.n157 vdd.n133 14.0005
R50 vdd.n37 vdd.n26 14.0005
R51 vdd.n41 vdd.n22 14.0005
R52 vdd.n44 vdd.n20 14.0005
R53 vdd.n69 vdd.n58 14.0005
R54 vdd.n73 vdd.n54 14.0005
R55 vdd.n76 vdd.n52 14.0005
R56 vdd vdd.n179 13.5005
R57 vdd.n96 vdd.n95 6.37187
R58 vdd.n96 vdd.n83 6.37187
R59 vdd.n127 vdd.n101 6.37187
R60 vdd.n122 vdd.n100 6.37187
R61 vdd.n159 vdd.n133 6.37187
R62 vdd.n154 vdd.n132 6.37187
R63 vdd.n15 vdd.n14 6.37187
R64 vdd.n15 vdd.n2 6.37187
R65 vdd.n46 vdd.n20 6.37187
R66 vdd.n41 vdd.n19 6.37187
R67 vdd.n78 vdd.n52 6.37187
R68 vdd.n73 vdd.n51 6.37187
R69 vdd.n177 vdd.n176 6.37187
R70 vdd.n177 vdd.n164 6.37187
R71 vdd.n91 vdd.n90 6.3005
R72 vdd.n87 vdd.n86 6.3005
R73 vdd.n113 vdd.n112 6.3005
R74 vdd.n108 vdd.n107 6.3005
R75 vdd.n118 vdd.n117 6.3005
R76 vdd.n120 vdd.n105 6.3005
R77 vdd.n123 vdd.n101 6.3005
R78 vdd.n126 vdd.n125 6.3005
R79 vdd.n103 vdd.n102 6.3005
R80 vdd.n123 vdd.n122 6.3005
R81 vdd.n145 vdd.n144 6.3005
R82 vdd.n140 vdd.n139 6.3005
R83 vdd.n150 vdd.n149 6.3005
R84 vdd.n152 vdd.n137 6.3005
R85 vdd.n155 vdd.n133 6.3005
R86 vdd.n158 vdd.n157 6.3005
R87 vdd.n135 vdd.n134 6.3005
R88 vdd.n155 vdd.n154 6.3005
R89 vdd.n10 vdd.n9 6.3005
R90 vdd.n6 vdd.n5 6.3005
R91 vdd.n32 vdd.n31 6.3005
R92 vdd.n27 vdd.n26 6.3005
R93 vdd.n37 vdd.n36 6.3005
R94 vdd.n39 vdd.n24 6.3005
R95 vdd.n42 vdd.n20 6.3005
R96 vdd.n45 vdd.n44 6.3005
R97 vdd.n22 vdd.n21 6.3005
R98 vdd.n42 vdd.n41 6.3005
R99 vdd.n64 vdd.n63 6.3005
R100 vdd.n59 vdd.n58 6.3005
R101 vdd.n69 vdd.n68 6.3005
R102 vdd.n71 vdd.n56 6.3005
R103 vdd.n74 vdd.n52 6.3005
R104 vdd.n77 vdd.n76 6.3005
R105 vdd.n54 vdd.n53 6.3005
R106 vdd.n74 vdd.n73 6.3005
R107 vdd.n172 vdd.n171 6.3005
R108 vdd.n168 vdd.n167 6.3005
R109 vdd.n88 vdd.n82 5.34137
R110 vdd.n89 vdd.n81 5.34137
R111 vdd.n7 vdd.n1 5.34137
R112 vdd.n8 vdd.n0 5.34137
R113 vdd.n109 vdd.n99 5.20888
R114 vdd.n114 vdd.n98 5.20888
R115 vdd.n141 vdd.n131 5.20888
R116 vdd.n146 vdd.n130 5.20888
R117 vdd.n28 vdd.n18 5.20888
R118 vdd.n33 vdd.n17 5.20888
R119 vdd.n60 vdd.n50 5.20888
R120 vdd.n65 vdd.n49 5.20888
R121 vdd.n169 vdd.n163 5.19561
R122 vdd.n170 vdd.n162 5.19561
R123 vdd.n97 vdd.n81 5.12897
R124 vdd.n16 vdd.n0 5.12897
R125 vdd.n97 vdd.n82 5.12115
R126 vdd.n16 vdd.n1 5.12115
R127 vdd.n128 vdd.n98 5.02528
R128 vdd.n160 vdd.n130 5.02528
R129 vdd.n47 vdd.n17 5.02528
R130 vdd.n79 vdd.n49 5.02528
R131 vdd.n128 vdd.n99 5.01745
R132 vdd.n160 vdd.n131 5.01745
R133 vdd.n47 vdd.n18 5.01745
R134 vdd.n79 vdd.n50 5.01745
R135 vdd.n178 vdd.n162 4.98321
R136 vdd.n178 vdd.n163 4.97539
R137 vdd.n90 vdd.n89 4.5005
R138 vdd.n88 vdd.n87 4.5005
R139 vdd.n117 vdd.n116 4.5005
R140 vdd.n115 vdd.n108 4.5005
R141 vdd.n114 vdd.n113 4.5005
R142 vdd.n109 vdd.n105 4.5005
R143 vdd.n149 vdd.n148 4.5005
R144 vdd.n147 vdd.n140 4.5005
R145 vdd.n146 vdd.n145 4.5005
R146 vdd.n141 vdd.n137 4.5005
R147 vdd.n9 vdd.n8 4.5005
R148 vdd.n7 vdd.n6 4.5005
R149 vdd.n36 vdd.n35 4.5005
R150 vdd.n34 vdd.n27 4.5005
R151 vdd.n33 vdd.n32 4.5005
R152 vdd.n28 vdd.n24 4.5005
R153 vdd.n68 vdd.n67 4.5005
R154 vdd.n66 vdd.n59 4.5005
R155 vdd.n65 vdd.n64 4.5005
R156 vdd.n60 vdd.n56 4.5005
R157 vdd.n171 vdd.n170 4.5005
R158 vdd.n169 vdd.n168 4.5005
R159 vdd.n91 vdd.n85 3.31679
R160 vdd.n86 vdd.n85 3.31679
R161 vdd.n94 vdd.n83 3.31679
R162 vdd.n95 vdd.n94 3.31679
R163 vdd.n119 vdd.n118 3.31679
R164 vdd.n112 vdd.n110 3.31679
R165 vdd.n110 vdd.n107 3.31679
R166 vdd.n120 vdd.n119 3.31679
R167 vdd.n125 vdd.n124 3.31679
R168 vdd.n124 vdd.n103 3.31679
R169 vdd.n151 vdd.n150 3.31679
R170 vdd.n144 vdd.n142 3.31679
R171 vdd.n142 vdd.n139 3.31679
R172 vdd.n152 vdd.n151 3.31679
R173 vdd.n157 vdd.n156 3.31679
R174 vdd.n156 vdd.n135 3.31679
R175 vdd.n11 vdd.n10 3.31679
R176 vdd.n11 vdd.n5 3.31679
R177 vdd.n13 vdd.n2 3.31679
R178 vdd.n14 vdd.n13 3.31679
R179 vdd.n38 vdd.n37 3.31679
R180 vdd.n31 vdd.n29 3.31679
R181 vdd.n29 vdd.n26 3.31679
R182 vdd.n39 vdd.n38 3.31679
R183 vdd.n44 vdd.n43 3.31679
R184 vdd.n43 vdd.n22 3.31679
R185 vdd.n70 vdd.n69 3.31679
R186 vdd.n63 vdd.n61 3.31679
R187 vdd.n61 vdd.n58 3.31679
R188 vdd.n71 vdd.n70 3.31679
R189 vdd.n76 vdd.n75 3.31679
R190 vdd.n75 vdd.n54 3.31679
R191 vdd.n173 vdd.n172 3.31679
R192 vdd.n173 vdd.n167 3.31679
R193 vdd.n175 vdd.n164 3.31679
R194 vdd.n176 vdd.n175 3.31679
R195 vdd.n97 vdd.n96 2.21557
R196 vdd.n128 vdd.n100 2.21557
R197 vdd.n128 vdd.n127 2.21557
R198 vdd.n160 vdd.n132 2.21557
R199 vdd.n160 vdd.n159 2.21557
R200 vdd.n16 vdd.n15 2.21557
R201 vdd.n47 vdd.n19 2.21557
R202 vdd.n47 vdd.n46 2.21557
R203 vdd.n79 vdd.n51 2.21557
R204 vdd.n79 vdd.n78 2.21557
R205 vdd.n178 vdd.n177 2.21557
R206 vdd.n110 vdd.n106 1.49311
R207 vdd.n119 vdd.n106 1.49311
R208 vdd.n124 vdd.n123 1.49311
R209 vdd.n142 vdd.n138 1.49311
R210 vdd.n151 vdd.n138 1.49311
R211 vdd.n156 vdd.n155 1.49311
R212 vdd.n29 vdd.n25 1.49311
R213 vdd.n38 vdd.n25 1.49311
R214 vdd.n43 vdd.n42 1.49311
R215 vdd.n61 vdd.n57 1.49311
R216 vdd.n70 vdd.n57 1.49311
R217 vdd.n75 vdd.n74 1.49311
R218 vdd.n165 vdd.n162 0.9005
R219 vdd.n174 vdd.n165 0.9005
R220 vdd.n166 vdd.n163 0.9005
R221 vdd.n174 vdd.n166 0.9005
R222 vdd.n111 vdd.n98 0.788
R223 vdd.n111 vdd.n104 0.788
R224 vdd.n121 vdd.n99 0.788
R225 vdd.n121 vdd.n104 0.788
R226 vdd.n143 vdd.n130 0.788
R227 vdd.n143 vdd.n136 0.788
R228 vdd.n153 vdd.n131 0.788
R229 vdd.n153 vdd.n136 0.788
R230 vdd.n30 vdd.n17 0.788
R231 vdd.n30 vdd.n23 0.788
R232 vdd.n40 vdd.n18 0.788
R233 vdd.n40 vdd.n23 0.788
R234 vdd.n62 vdd.n49 0.788
R235 vdd.n62 vdd.n55 0.788
R236 vdd.n72 vdd.n50 0.788
R237 vdd.n72 vdd.n55 0.788
R238 vdd.n129 vdd.n97 0.667685
R239 vdd.n48 vdd.n16 0.667685
R240 vdd.n92 vdd.n81 0.6305
R241 vdd.n93 vdd.n92 0.6305
R242 vdd.n84 vdd.n82 0.6305
R243 vdd.n93 vdd.n84 0.6305
R244 vdd.n3 vdd.n0 0.6305
R245 vdd.n12 vdd.n3 0.6305
R246 vdd.n4 vdd.n1 0.6305
R247 vdd.n12 vdd.n4 0.6305
R248 vdd.n161 vdd.n129 0.5549
R249 vdd.n80 vdd.n48 0.5549
R250 vdd.n179 vdd.n80 0.5549
R251 vdd.n179 vdd.n161 0.5549
R252 vdd.n179 vdd.n178 0.155722
R253 vdd.n90 vdd.n87 0.1445
R254 vdd.n89 vdd.n88 0.1445
R255 vdd.n117 vdd.n105 0.1445
R256 vdd.n117 vdd.n108 0.1445
R257 vdd.n113 vdd.n108 0.1445
R258 vdd.n116 vdd.n109 0.1445
R259 vdd.n116 vdd.n115 0.1445
R260 vdd.n115 vdd.n114 0.1445
R261 vdd.n126 vdd.n102 0.1445
R262 vdd.n149 vdd.n137 0.1445
R263 vdd.n149 vdd.n140 0.1445
R264 vdd.n145 vdd.n140 0.1445
R265 vdd.n148 vdd.n141 0.1445
R266 vdd.n148 vdd.n147 0.1445
R267 vdd.n147 vdd.n146 0.1445
R268 vdd.n158 vdd.n134 0.1445
R269 vdd.n9 vdd.n6 0.1445
R270 vdd.n8 vdd.n7 0.1445
R271 vdd.n36 vdd.n24 0.1445
R272 vdd.n36 vdd.n27 0.1445
R273 vdd.n32 vdd.n27 0.1445
R274 vdd.n35 vdd.n28 0.1445
R275 vdd.n35 vdd.n34 0.1445
R276 vdd.n34 vdd.n33 0.1445
R277 vdd.n45 vdd.n21 0.1445
R278 vdd.n68 vdd.n56 0.1445
R279 vdd.n68 vdd.n59 0.1445
R280 vdd.n64 vdd.n59 0.1445
R281 vdd.n67 vdd.n60 0.1445
R282 vdd.n67 vdd.n66 0.1445
R283 vdd.n66 vdd.n65 0.1445
R284 vdd.n77 vdd.n53 0.1445
R285 vdd.n171 vdd.n168 0.1445
R286 vdd.n170 vdd.n169 0.1445
R287 vdd.n129 vdd.n128 0.102257
R288 vdd.n161 vdd.n160 0.102257
R289 vdd.n48 vdd.n47 0.102257
R290 vdd.n80 vdd.n79 0.102257
R291 vdd.n102 vdd.n100 0.0718661
R292 vdd.n127 vdd.n126 0.0718661
R293 vdd.n134 vdd.n132 0.0718661
R294 vdd.n159 vdd.n158 0.0718661
R295 vdd.n21 vdd.n19 0.0718661
R296 vdd.n46 vdd.n45 0.0718661
R297 vdd.n53 vdd.n51 0.0718661
R298 vdd.n78 vdd.n77 0.0718661
R299 vss.n208 vss.n207 16945.1
R300 vss.n126 vss.n125 11700.7
R301 vss.n126 vss.n7 10887.5
R302 vss.n207 vss.n163 10887.5
R303 vss.n206 vss.n143 10887.5
R304 vss.n259 vss.n128 10111.1
R305 vss.n127 vss.n6 10111.1
R306 vss.n207 vss.n206 4830.04
R307 vss.n127 vss.n126 4784.76
R308 vss.n206 vss.n128 4784.76
R309 vss.n128 vss.n127 3693.99
R310 vss.n142 vss.n134 793.182
R311 vss.n66 vss.n6 577.389
R312 vss.n260 vss.n259 577.389
R313 vss.n84 vss.n79 396.591
R314 vss.n260 vss.n5 396.591
R315 vss.n258 vss.n129 396.591
R316 vss.n251 vss.n134 396.591
R317 vss.n125 vss.n8 370.346
R318 vss.n94 vss.n66 370.346
R319 vss.n208 vss.n175 370.346
R320 vss.n17 vss.n8 233.288
R321 vss.n117 vss.n17 233.288
R322 vss.n117 vss.n116 233.288
R323 vss.n116 vss.n115 233.288
R324 vss.n115 vss.n21 233.288
R325 vss.n109 vss.n21 233.288
R326 vss.n109 vss.n108 233.288
R327 vss.n102 vss.n51 233.288
R328 vss.n102 vss.n52 233.288
R329 vss.n96 vss.n52 233.288
R330 vss.n96 vss.n95 233.288
R331 vss.n95 vss.n94 233.288
R332 vss.n84 vss.n5 233.288
R333 vss.n251 vss.n129 233.288
R334 vss.n241 vss.n144 233.288
R335 vss.n233 vss.n144 233.288
R336 vss.n233 vss.n232 233.288
R337 vss.n232 vss.n231 233.288
R338 vss.n231 vss.n153 233.288
R339 vss.n225 vss.n153 233.288
R340 vss.n225 vss.n224 233.288
R341 vss.n224 vss.n223 233.288
R342 vss.n217 vss.n171 233.288
R343 vss.n217 vss.n216 233.288
R344 vss.n216 vss.n215 233.288
R345 vss.n215 vss.n175 233.288
R346 vss.n79 vss.n6 215.792
R347 vss.n259 vss.n258 215.792
R348 vss.n241 vss.n143 212.876
R349 vss.n143 vss.n142 157.47
R350 vss.n108 vss.n7 154.554
R351 vss.n171 vss.n163 119.561
R352 vss.n223 vss.n163 113.728
R353 vss.n51 vss.n7 78.7354
R354 vss.n252 vss.n133 68.4449
R355 vss.n250 vss.n133 68.4449
R356 vss.n257 vss.n131 68.4449
R357 vss.n257 vss.n130 68.4449
R358 vss.n83 vss.n78 68.4449
R359 vss.n261 vss.n3 68.4449
R360 vss.n85 vss.n78 68.4449
R361 vss.n261 vss.n4 68.4449
R362 vss.n240 vss.n140 66.6949
R363 vss.n209 vss.n176 66.6949
R364 vss.n209 vss.n205 66.6949
R365 vss.n242 vss.n140 66.6949
R366 vss.n67 vss.n65 66.6949
R367 vss.n93 vss.n67 66.6949
R368 vss.n124 vss.n10 66.6949
R369 vss.n124 vss.n9 66.6949
R370 vss.n240 vss.n145 15.5561
R371 vss.n234 vss.n145 15.5561
R372 vss.n234 vss.n149 15.5561
R373 vss.n230 vss.n149 15.5561
R374 vss.n230 vss.n154 15.5561
R375 vss.n226 vss.n154 15.5561
R376 vss.n226 vss.n159 15.5561
R377 vss.n222 vss.n159 15.5561
R378 vss.n222 vss.n164 15.5561
R379 vss.n218 vss.n164 15.5561
R380 vss.n218 vss.n170 15.5561
R381 vss.n214 vss.n170 15.5561
R382 vss.n214 vss.n176 15.5561
R383 vss.n242 vss.n141 15.5561
R384 vss.n150 vss.n141 15.5561
R385 vss.n151 vss.n150 15.5561
R386 vss.n152 vss.n151 15.5561
R387 vss.n190 vss.n152 15.5561
R388 vss.n190 vss.n160 15.5561
R389 vss.n161 vss.n160 15.5561
R390 vss.n162 vss.n161 15.5561
R391 vss.n197 vss.n162 15.5561
R392 vss.n197 vss.n172 15.5561
R393 vss.n173 vss.n172 15.5561
R394 vss.n174 vss.n173 15.5561
R395 vss.n205 vss.n174 15.5561
R396 vss.n250 vss.n131 15.5561
R397 vss.n252 vss.n130 15.5561
R398 vss.n13 vss.n10 15.5561
R399 vss.n118 vss.n13 15.5561
R400 vss.n118 vss.n16 15.5561
R401 vss.n114 vss.n16 15.5561
R402 vss.n114 vss.n22 15.5561
R403 vss.n110 vss.n22 15.5561
R404 vss.n110 vss.n28 15.5561
R405 vss.n53 vss.n28 15.5561
R406 vss.n101 vss.n53 15.5561
R407 vss.n101 vss.n54 15.5561
R408 vss.n97 vss.n54 15.5561
R409 vss.n97 vss.n62 15.5561
R410 vss.n93 vss.n62 15.5561
R411 vss.n35 vss.n9 15.5561
R412 vss.n35 vss.n18 15.5561
R413 vss.n19 vss.n18 15.5561
R414 vss.n20 vss.n19 15.5561
R415 vss.n42 vss.n20 15.5561
R416 vss.n42 vss.n29 15.5561
R417 vss.n107 vss.n29 15.5561
R418 vss.n107 vss.n30 15.5561
R419 vss.n103 vss.n30 15.5561
R420 vss.n103 vss.n50 15.5561
R421 vss.n63 vss.n50 15.5561
R422 vss.n64 vss.n63 15.5561
R423 vss.n65 vss.n64 15.5561
R424 vss.n83 vss.n3 15.5561
R425 vss.n85 vss.n4 15.5561
R426 vss vss.n264 13.5005
R427 vss.n74 vss.n65 5.2005
R428 vss.n94 vss.n65 5.2005
R429 vss.n73 vss.n64 5.2005
R430 vss.n95 vss.n64 5.2005
R431 vss.n72 vss.n63 5.2005
R432 vss.n96 vss.n63 5.2005
R433 vss.n50 vss.n49 5.2005
R434 vss.n52 vss.n50 5.2005
R435 vss.n104 vss.n103 5.2005
R436 vss.n103 vss.n102 5.2005
R437 vss.n105 vss.n30 5.2005
R438 vss.n51 vss.n30 5.2005
R439 vss.n107 vss.n106 5.2005
R440 vss.n108 vss.n107 5.2005
R441 vss.n31 vss.n29 5.2005
R442 vss.n109 vss.n29 5.2005
R443 vss.n43 vss.n42 5.2005
R444 vss.n42 vss.n21 5.2005
R445 vss.n41 vss.n20 5.2005
R446 vss.n115 vss.n20 5.2005
R447 vss.n40 vss.n19 5.2005
R448 vss.n116 vss.n19 5.2005
R449 vss.n33 vss.n18 5.2005
R450 vss.n117 vss.n18 5.2005
R451 vss.n36 vss.n35 5.2005
R452 vss.n35 vss.n17 5.2005
R453 vss.n34 vss.n9 5.2005
R454 vss.n9 vss.n8 5.2005
R455 vss.n93 vss.n92 5.2005
R456 vss.n94 vss.n93 5.2005
R457 vss.n62 vss.n61 5.2005
R458 vss.n95 vss.n62 5.2005
R459 vss.n98 vss.n97 5.2005
R460 vss.n97 vss.n96 5.2005
R461 vss.n99 vss.n54 5.2005
R462 vss.n54 vss.n52 5.2005
R463 vss.n101 vss.n100 5.2005
R464 vss.n102 vss.n101 5.2005
R465 vss.n55 vss.n53 5.2005
R466 vss.n53 vss.n51 5.2005
R467 vss.n28 vss.n27 5.2005
R468 vss.n108 vss.n28 5.2005
R469 vss.n111 vss.n110 5.2005
R470 vss.n110 vss.n109 5.2005
R471 vss.n112 vss.n22 5.2005
R472 vss.n22 vss.n21 5.2005
R473 vss.n114 vss.n113 5.2005
R474 vss.n115 vss.n114 5.2005
R475 vss.n16 vss.n15 5.2005
R476 vss.n116 vss.n16 5.2005
R477 vss.n119 vss.n118 5.2005
R478 vss.n118 vss.n117 5.2005
R479 vss.n120 vss.n13 5.2005
R480 vss.n17 vss.n13 5.2005
R481 vss.n121 vss.n10 5.2005
R482 vss.n10 vss.n8 5.2005
R483 vss.n253 vss.n252 5.2005
R484 vss.n252 vss.n251 5.2005
R485 vss.n254 vss.n130 5.2005
R486 vss.n130 vss.n129 5.2005
R487 vss.n250 vss.n249 5.2005
R488 vss.n251 vss.n250 5.2005
R489 vss.n135 vss.n131 5.2005
R490 vss.n131 vss.n129 5.2005
R491 vss.n205 vss.n204 5.2005
R492 vss.n205 vss.n175 5.2005
R493 vss.n203 vss.n174 5.2005
R494 vss.n215 vss.n174 5.2005
R495 vss.n180 vss.n173 5.2005
R496 vss.n216 vss.n173 5.2005
R497 vss.n199 vss.n172 5.2005
R498 vss.n217 vss.n172 5.2005
R499 vss.n198 vss.n197 5.2005
R500 vss.n197 vss.n171 5.2005
R501 vss.n196 vss.n162 5.2005
R502 vss.n223 vss.n162 5.2005
R503 vss.n182 vss.n161 5.2005
R504 vss.n224 vss.n161 5.2005
R505 vss.n192 vss.n160 5.2005
R506 vss.n225 vss.n160 5.2005
R507 vss.n191 vss.n190 5.2005
R508 vss.n190 vss.n153 5.2005
R509 vss.n189 vss.n152 5.2005
R510 vss.n231 vss.n152 5.2005
R511 vss.n184 vss.n151 5.2005
R512 vss.n232 vss.n151 5.2005
R513 vss.n185 vss.n150 5.2005
R514 vss.n233 vss.n150 5.2005
R515 vss.n141 vss.n139 5.2005
R516 vss.n144 vss.n141 5.2005
R517 vss.n243 vss.n242 5.2005
R518 vss.n242 vss.n241 5.2005
R519 vss.n240 vss.n239 5.2005
R520 vss.n241 vss.n240 5.2005
R521 vss.n146 vss.n145 5.2005
R522 vss.n145 vss.n144 5.2005
R523 vss.n235 vss.n234 5.2005
R524 vss.n234 vss.n233 5.2005
R525 vss.n149 vss.n148 5.2005
R526 vss.n232 vss.n149 5.2005
R527 vss.n230 vss.n229 5.2005
R528 vss.n231 vss.n230 5.2005
R529 vss.n228 vss.n154 5.2005
R530 vss.n154 vss.n153 5.2005
R531 vss.n227 vss.n226 5.2005
R532 vss.n226 vss.n225 5.2005
R533 vss.n159 vss.n158 5.2005
R534 vss.n224 vss.n159 5.2005
R535 vss.n222 vss.n221 5.2005
R536 vss.n223 vss.n222 5.2005
R537 vss.n220 vss.n164 5.2005
R538 vss.n171 vss.n164 5.2005
R539 vss.n219 vss.n218 5.2005
R540 vss.n218 vss.n217 5.2005
R541 vss.n170 vss.n169 5.2005
R542 vss.n216 vss.n170 5.2005
R543 vss.n214 vss.n213 5.2005
R544 vss.n215 vss.n214 5.2005
R545 vss.n212 vss.n176 5.2005
R546 vss.n176 vss.n175 5.2005
R547 vss.n80 vss.n3 5.2005
R548 vss.n5 vss.n3 5.2005
R549 vss.n83 vss.n82 5.2005
R550 vss.n84 vss.n83 5.2005
R551 vss.n86 vss.n4 5.2005
R552 vss.n5 vss.n4 5.2005
R553 vss.n87 vss.n85 5.2005
R554 vss.n85 vss.n84 5.2005
R555 vss.n246 vss.n132 5.19561
R556 vss.n262 vss.n2 5.19561
R557 vss.n256 vss.n255 5.18779
R558 vss.n81 vss.n77 5.18779
R559 vss.n238 vss.n137 5.17941
R560 vss.n211 vss.n210 5.17941
R561 vss.n76 vss.n75 5.17941
R562 vss.n123 vss.n11 5.17941
R563 vss.n210 vss.n179 5.01157
R564 vss.n123 vss.n122 5.01157
R565 vss.n247 vss.n246 4.98321
R566 vss.n245 vss.n137 4.98321
R567 vss.n256 vss.n1 4.98321
R568 vss.n90 vss.n76 4.98321
R569 vss.n263 vss.n262 4.98321
R570 vss.n89 vss.n77 4.98321
R571 vss.n239 vss.n238 4.5005
R572 vss.n237 vss.n146 4.5005
R573 vss.n236 vss.n235 4.5005
R574 vss.n148 vss.n147 4.5005
R575 vss.n229 vss.n155 4.5005
R576 vss.n228 vss.n156 4.5005
R577 vss.n227 vss.n157 4.5005
R578 vss.n165 vss.n158 4.5005
R579 vss.n221 vss.n166 4.5005
R580 vss.n220 vss.n167 4.5005
R581 vss.n219 vss.n168 4.5005
R582 vss.n177 vss.n169 4.5005
R583 vss.n213 vss.n178 4.5005
R584 vss.n212 vss.n211 4.5005
R585 vss.n139 vss.n138 4.5005
R586 vss.n186 vss.n185 4.5005
R587 vss.n187 vss.n184 4.5005
R588 vss.n189 vss.n188 4.5005
R589 vss.n191 vss.n183 4.5005
R590 vss.n193 vss.n192 4.5005
R591 vss.n194 vss.n182 4.5005
R592 vss.n196 vss.n195 4.5005
R593 vss.n198 vss.n181 4.5005
R594 vss.n200 vss.n199 4.5005
R595 vss.n201 vss.n180 4.5005
R596 vss.n203 vss.n202 4.5005
R597 vss.n204 vss.n179 4.5005
R598 vss.n244 vss.n243 4.5005
R599 vss.n249 vss.n248 4.5005
R600 vss.n136 vss.n135 4.5005
R601 vss.n253 vss.n132 4.5005
R602 vss.n255 vss.n254 4.5005
R603 vss.n120 vss.n12 4.5005
R604 vss.n119 vss.n14 4.5005
R605 vss.n23 vss.n15 4.5005
R606 vss.n113 vss.n24 4.5005
R607 vss.n112 vss.n25 4.5005
R608 vss.n111 vss.n26 4.5005
R609 vss.n56 vss.n27 4.5005
R610 vss.n57 vss.n55 4.5005
R611 vss.n100 vss.n58 4.5005
R612 vss.n99 vss.n59 4.5005
R613 vss.n98 vss.n60 4.5005
R614 vss.n68 vss.n61 4.5005
R615 vss.n92 vss.n91 4.5005
R616 vss.n122 vss.n121 4.5005
R617 vss.n37 vss.n36 4.5005
R618 vss.n38 vss.n33 4.5005
R619 vss.n40 vss.n39 4.5005
R620 vss.n41 vss.n32 4.5005
R621 vss.n44 vss.n43 4.5005
R622 vss.n45 vss.n31 4.5005
R623 vss.n106 vss.n46 4.5005
R624 vss.n105 vss.n47 4.5005
R625 vss.n104 vss.n48 4.5005
R626 vss.n70 vss.n49 4.5005
R627 vss.n72 vss.n71 4.5005
R628 vss.n73 vss.n69 4.5005
R629 vss.n75 vss.n74 4.5005
R630 vss.n34 vss.n11 4.5005
R631 vss.n80 vss.n2 4.5005
R632 vss.n82 vss.n81 4.5005
R633 vss.n86 vss.n0 4.5005
R634 vss.n88 vss.n87 4.5005
R635 vss.n124 vss.n123 0.743357
R636 vss.n125 vss.n124 0.743357
R637 vss.n76 vss.n67 0.743357
R638 vss.n67 vss.n66 0.743357
R639 vss.n257 vss.n256 0.743357
R640 vss.n258 vss.n257 0.743357
R641 vss.n246 vss.n133 0.743357
R642 vss.n134 vss.n133 0.743357
R643 vss.n140 vss.n137 0.743357
R644 vss.n142 vss.n140 0.743357
R645 vss.n210 vss.n209 0.743357
R646 vss.n209 vss.n208 0.743357
R647 vss.n262 vss.n261 0.743357
R648 vss.n261 vss.n260 0.743357
R649 vss.n78 vss.n77 0.743357
R650 vss.n79 vss.n78 0.743357
R651 vss.n263 vss.n1 0.5549
R652 vss.n247 vss.n245 0.5549
R653 vss.n90 vss.n89 0.5549
R654 vss.n87 vss.n86 0.1445
R655 vss.n249 vss.n135 0.1445
R656 vss.n243 vss.n139 0.1445
R657 vss.n185 vss.n139 0.1445
R658 vss.n185 vss.n184 0.1445
R659 vss.n189 vss.n184 0.1445
R660 vss.n191 vss.n189 0.1445
R661 vss.n192 vss.n191 0.1445
R662 vss.n192 vss.n182 0.1445
R663 vss.n196 vss.n182 0.1445
R664 vss.n198 vss.n196 0.1445
R665 vss.n199 vss.n198 0.1445
R666 vss.n199 vss.n180 0.1445
R667 vss.n203 vss.n180 0.1445
R668 vss.n204 vss.n203 0.1445
R669 vss.n239 vss.n146 0.1445
R670 vss.n235 vss.n146 0.1445
R671 vss.n235 vss.n148 0.1445
R672 vss.n229 vss.n148 0.1445
R673 vss.n229 vss.n228 0.1445
R674 vss.n228 vss.n227 0.1445
R675 vss.n227 vss.n158 0.1445
R676 vss.n221 vss.n158 0.1445
R677 vss.n221 vss.n220 0.1445
R678 vss.n220 vss.n219 0.1445
R679 vss.n219 vss.n169 0.1445
R680 vss.n213 vss.n169 0.1445
R681 vss.n213 vss.n212 0.1445
R682 vss.n238 vss.n237 0.1445
R683 vss.n237 vss.n236 0.1445
R684 vss.n236 vss.n147 0.1445
R685 vss.n155 vss.n147 0.1445
R686 vss.n156 vss.n155 0.1445
R687 vss.n157 vss.n156 0.1445
R688 vss.n165 vss.n157 0.1445
R689 vss.n166 vss.n165 0.1445
R690 vss.n167 vss.n166 0.1445
R691 vss.n168 vss.n167 0.1445
R692 vss.n177 vss.n168 0.1445
R693 vss.n178 vss.n177 0.1445
R694 vss.n211 vss.n178 0.1445
R695 vss.n255 vss.n132 0.1445
R696 vss.n254 vss.n253 0.1445
R697 vss.n121 vss.n120 0.1445
R698 vss.n120 vss.n119 0.1445
R699 vss.n119 vss.n15 0.1445
R700 vss.n113 vss.n15 0.1445
R701 vss.n113 vss.n112 0.1445
R702 vss.n112 vss.n111 0.1445
R703 vss.n111 vss.n27 0.1445
R704 vss.n55 vss.n27 0.1445
R705 vss.n100 vss.n55 0.1445
R706 vss.n100 vss.n99 0.1445
R707 vss.n99 vss.n98 0.1445
R708 vss.n98 vss.n61 0.1445
R709 vss.n92 vss.n61 0.1445
R710 vss.n37 vss.n11 0.1445
R711 vss.n38 vss.n37 0.1445
R712 vss.n39 vss.n38 0.1445
R713 vss.n39 vss.n32 0.1445
R714 vss.n44 vss.n32 0.1445
R715 vss.n45 vss.n44 0.1445
R716 vss.n46 vss.n45 0.1445
R717 vss.n47 vss.n46 0.1445
R718 vss.n48 vss.n47 0.1445
R719 vss.n70 vss.n48 0.1445
R720 vss.n71 vss.n70 0.1445
R721 vss.n71 vss.n69 0.1445
R722 vss.n75 vss.n69 0.1445
R723 vss.n36 vss.n34 0.1445
R724 vss.n36 vss.n33 0.1445
R725 vss.n40 vss.n33 0.1445
R726 vss.n41 vss.n40 0.1445
R727 vss.n43 vss.n41 0.1445
R728 vss.n43 vss.n31 0.1445
R729 vss.n106 vss.n31 0.1445
R730 vss.n106 vss.n105 0.1445
R731 vss.n105 vss.n104 0.1445
R732 vss.n104 vss.n49 0.1445
R733 vss.n72 vss.n49 0.1445
R734 vss.n73 vss.n72 0.1445
R735 vss.n74 vss.n73 0.1445
R736 vss.n82 vss.n80 0.1445
R737 vss.n81 vss.n2 0.1445
R738 vss.n136 vss.n1 0.0311936
R739 vss.n248 vss.n247 0.0311936
R740 vss.n89 vss.n88 0.0311936
R741 vss.n245 vss.n244 0.0288526
R742 vss.n91 vss.n90 0.0288526
R743 vss.n264 vss.n263 0.0254711
R744 vss.n244 vss.n138 0.0213092
R745 vss.n186 vss.n138 0.0213092
R746 vss.n187 vss.n186 0.0213092
R747 vss.n188 vss.n187 0.0213092
R748 vss.n188 vss.n183 0.0213092
R749 vss.n193 vss.n183 0.0213092
R750 vss.n194 vss.n193 0.0213092
R751 vss.n195 vss.n194 0.0213092
R752 vss.n195 vss.n181 0.0213092
R753 vss.n200 vss.n181 0.0213092
R754 vss.n201 vss.n200 0.0213092
R755 vss.n202 vss.n201 0.0213092
R756 vss.n202 vss.n179 0.0213092
R757 vss.n248 vss.n136 0.0213092
R758 vss.n122 vss.n12 0.0213092
R759 vss.n14 vss.n12 0.0213092
R760 vss.n23 vss.n14 0.0213092
R761 vss.n24 vss.n23 0.0213092
R762 vss.n25 vss.n24 0.0213092
R763 vss.n26 vss.n25 0.0213092
R764 vss.n56 vss.n26 0.0213092
R765 vss.n57 vss.n56 0.0213092
R766 vss.n58 vss.n57 0.0213092
R767 vss.n59 vss.n58 0.0213092
R768 vss.n60 vss.n59 0.0213092
R769 vss.n68 vss.n60 0.0213092
R770 vss.n91 vss.n68 0.0213092
R771 vss.n88 vss.n0 0.0213092
R772 vss.n264 vss.n0 0.00622254
C0 xm9_0/a_n50_n339# Iex_1_i 0.02805f
C1 xm3_0/a_28_n281# xm9_0/a_28_n131# 0.03085f
C2 vdd xm9_0/a_n50_n339# 0.94878f
C3 Iex_2_i Iex_1_i 0.02909f
C4 vdd Iex_2_i 0.33962f
C5 xm3_0/a_28_n281# Vin 0.01343f
C6 xm3_0/a_28_n281# xm9_0/a_n50_n339# 0.02036f
C7 xm3_0/a_28_n281# Iex_2_i 0.09127f
C8 Iex_3_i xm9_0/a_28_n131# 0.00108f
C9 Vin xm9_0/a_28_n131# 0.05542f
C10 Vin_neg Iex_4_i 0
C11 xm4_0/a_28_n281# Vin_neg 0.01177f
C12 xm4_0/a_28_n281# Iex_4_i 0.0582f
C13 xm9_0/a_n50_n339# xm9_0/a_28_n131# 0.23845f
C14 vdd Vin_neg 0.012f
C15 vdd Iex_4_i 0.34225f
C16 xm4_0/a_28_n281# vdd 1.82822f
C17 vdd Iex_1_i 0.35521f
C18 Iex_2_i xm9_0/a_28_n131# 0
C19 xm9_0/a_n50_n339# Vin 0.00641f
C20 Iex_2_i Vin 0
C21 xm3_0/a_28_n281# Iex_1_i 0.02449f
C22 xm3_0/a_28_n281# vdd 1.7106f
C23 Vin_neg xm9_0/a_28_n131# 0.06065f
C24 Iex_4_i xm9_0/a_28_n131# 0.00108f
C25 xm4_0/a_28_n281# xm9_0/a_28_n131# 0.43354f
C26 xm9_0/a_28_n131# Iex_1_i 0.00147f
C27 vdd xm9_0/a_28_n131# 0.56303f
C28 Iex_3_i Vin_neg 0
C29 Iex_3_i Iex_4_i 0.02909f
C30 xm4_0/a_28_n281# Iex_3_i 0.10396f
C31 vdd Iex_3_i 0.33704f
C32 vdd Vin 0.0139f
C33 xm9_0/a_n50_n339# Vin_neg 0.0203f
C34 xm9_0/a_n50_n339# Iex_4_i 0.02938f
C35 xm4_0/a_28_n281# xm9_0/a_n50_n339# 0.03121f
C36 Iex_3_i vss 0.10759f
C37 vss.n0 vss 0.00352f
C38 vss.n1 vss 0.00613f
C39 vss.n2 vss 0.00206f
C40 vss.n3 vss 0.00163f
C41 vss.n4 vss 0.00163f
C42 vss.n5 vss 0.02398f
C43 vss.n6 vss 0.04024f
C44 vss.n7 vss 0.01969f
C45 vss.n8 vss 0.02298f
C46 vss.n9 vss 0.0016f
C47 vss.n10 vss 0.0016f
C48 vss.n11 vss 0.00197f
C49 vss.n12 vss 0.00551f
C50 vss.n13 vss 0
C51 vss.n14 vss 0.00551f
C52 vss.n15 vss 0
C53 vss.n16 vss 0
C54 vss.n17 vss 0.01776f
C55 vss.n18 vss 0
C56 vss.n19 vss 0
C57 vss.n20 vss 0
C58 vss.n21 vss 0.01776f
C59 vss.n22 vss 0
C60 vss.n23 vss 0.00551f
C61 vss.n24 vss 0.00551f
C62 vss.n25 vss 0.00551f
C63 vss.n26 vss 0.00551f
C64 vss.n27 vss 0
C65 vss.n28 vss 0
C66 vss.n29 vss 0
C67 vss.n30 vss 0
C68 vss.n31 vss 0
C69 vss.n32 vss 0
C70 vss.n33 vss 0
C71 vss.n34 vss 0
C72 vss.n35 vss 0
C73 vss.n36 vss 0
C74 vss.n37 vss 0
C75 vss.n38 vss 0
C76 vss.n39 vss 0
C77 vss.n40 vss 0
C78 vss.n41 vss 0
C79 vss.n42 vss 0
C80 vss.n43 vss 0
C81 vss.n44 vss 0
C82 vss.n45 vss 0
C83 vss.n46 vss 0
C84 vss.n47 vss 0
C85 vss.n48 vss 0
C86 vss.n49 vss 0
C87 vss.n50 vss 0
C88 vss.n51 vss 0.01188f
C89 vss.n52 vss 0.01776f
C90 vss.n53 vss 0
C91 vss.n54 vss 0
C92 vss.n55 vss 0
C93 vss.n56 vss 0.00551f
C94 vss.n57 vss 0.00551f
C95 vss.n58 vss 0.00551f
C96 vss.n59 vss 0.00551f
C97 vss.n60 vss 0.00551f
C98 vss.n61 vss 0
C99 vss.n62 vss 0
C100 vss.n63 vss 0
C101 vss.n64 vss 0
C102 vss.n65 vss 0.0016f
C103 vss.n66 vss 0.03608f
C104 vss.n67 vss 0.00256f
C105 vss.n68 vss 0.00551f
C106 vss.n69 vss 0
C107 vss.n70 vss 0
C108 vss.n71 vss 0
C109 vss.n72 vss 0
C110 vss.n73 vss 0
C111 vss.n74 vss 0
C112 vss.n75 vss 0.00197f
C113 vss.n76 vss 0.00463f
C114 vss.n77 vss 0.00765f
C115 vss.n78 vss 0.00262f
C116 vss.n79 vss 0.02332f
C117 vss.n80 vss 0
C118 vss.n81 vss 0.00213f
C119 vss.n82 vss 0
C120 vss.n83 vss 0.00163f
C121 vss.n84 vss 0.02398f
C122 vss.n85 vss 0.00163f
C123 vss.n86 vss 0
C124 vss.n87 vss 0
C125 vss.n88 vss 0.00682f
C126 vss.n89 vss 0.00613f
C127 vss.n90 vss 0.00582f
C128 vss.n91 vss 0.00651f
C129 vss.n92 vss 0
C130 vss.n93 vss 0.0016f
C131 vss.n94 vss 0.02298f
C132 vss.n95 vss 0.01776f
C133 vss.n96 vss 0.01776f
C134 vss.n97 vss 0
C135 vss.n98 vss 0
C136 vss.n99 vss 0
C137 vss.n100 vss 0
C138 vss.n101 vss 0
C139 vss.n102 vss 0.01776f
C140 vss.n103 vss 0
C141 vss.n104 vss 0
C142 vss.n105 vss 0
C143 vss.n106 vss 0
C144 vss.n107 vss 0
C145 vss.n108 vss 0.01477f
C146 vss.n109 vss 0.01776f
C147 vss.n110 vss 0
C148 vss.n111 vss 0
C149 vss.n112 vss 0
C150 vss.n113 vss 0
C151 vss.n114 vss 0
C152 vss.n115 vss 0.01776f
C153 vss.n116 vss 0.01776f
C154 vss.n117 vss 0.01776f
C155 vss.n118 vss 0
C156 vss.n119 vss 0
C157 vss.n120 vss 0
C158 vss.n121 vss 0
C159 vss.n122 vss 0.01078f
C160 vss.n123 vss 0.00465f
C161 vss.n124 vss 0.00256f
C162 vss.n125 vss 0.25616f
C163 vss.n126 vss 0.15812f
C164 vss.n127 vss 0.08312f
C165 vss.n128 vss 0.08312f
C166 vss.n129 vss 0.02398f
C167 vss.n130 vss 0.00163f
C168 vss.n131 vss 0.00163f
C169 vss.n132 vss 0.00206f
C170 vss.n133 vss 0.00262f
C171 vss.n134 vss 0.0453f
C172 vss.n135 vss 0
C173 vss.n136 vss 0.00682f
C174 vss.n137 vss 0.00463f
C175 vss.n138 vss 0.00551f
C176 vss.n139 vss 0
C177 vss.n140 vss 0.00256f
C178 vss.n141 vss 0
C179 vss.n142 vss 0.03619f
C180 vss.n143 vss 0.02491f
C181 vss.n144 vss 0.01776f
C182 vss.n145 vss 0
C183 vss.n146 vss 0
C184 vss.n147 vss 0
C185 vss.n148 vss 0
C186 vss.n149 vss 0
C187 vss.n150 vss 0
C188 vss.n151 vss 0
C189 vss.n152 vss 0
C190 vss.n153 vss 0.01776f
C191 vss.n154 vss 0
C192 vss.n155 vss 0
C193 vss.n156 vss 0
C194 vss.n157 vss 0
C195 vss.n158 vss 0
C196 vss.n159 vss 0
C197 vss.n160 vss 0
C198 vss.n161 vss 0
C199 vss.n162 vss 0
C200 vss.n163 vss 0.01969f
C201 vss.n164 vss 0
C202 vss.n165 vss 0
C203 vss.n166 vss 0
C204 vss.n167 vss 0
C205 vss.n168 vss 0
C206 vss.n169 vss 0
C207 vss.n170 vss 0
C208 vss.n171 vss 0.01343f
C209 vss.n172 vss 0
C210 vss.n173 vss 0
C211 vss.n174 vss 0
C212 vss.n175 vss 0.02298f
C213 vss.n176 vss 0.0016f
C214 vss.n177 vss 0
C215 vss.n178 vss 0
C216 vss.n179 vss 0.01078f
C217 vss.n180 vss 0
C218 vss.n181 vss 0.00551f
C219 vss.n182 vss 0
C220 vss.n183 vss 0.00551f
C221 vss.n184 vss 0
C222 vss.n185 vss 0
C223 vss.n186 vss 0.00551f
C224 vss.n187 vss 0.00551f
C225 vss.n188 vss 0.00551f
C226 vss.n189 vss 0
C227 vss.n190 vss 0
C228 vss.n191 vss 0
C229 vss.n192 vss 0
C230 vss.n193 vss 0.00551f
C231 vss.n194 vss 0.00551f
C232 vss.n195 vss 0.00551f
C233 vss.n196 vss 0
C234 vss.n197 vss 0
C235 vss.n198 vss 0
C236 vss.n199 vss 0
C237 vss.n200 vss 0.00551f
C238 vss.n201 vss 0.00551f
C239 vss.n202 vss 0.00551f
C240 vss.n203 vss 0
C241 vss.n204 vss 0
C242 vss.n205 vss 0.0016f
C243 vss.n206 vss 0.08635f
C244 vss.n207 vss 0.11076f
C245 vss.n208 vss 0.09534f
C246 vss.n209 vss 0.00256f
C247 vss.n210 vss 0.00465f
C248 vss.n211 vss 0.00197f
C249 vss.n212 vss 0
C250 vss.n213 vss 0
C251 vss.n214 vss 0
C252 vss.n215 vss 0.01776f
C253 vss.n216 vss 0.01776f
C254 vss.n217 vss 0.01776f
C255 vss.n218 vss 0
C256 vss.n219 vss 0
C257 vss.n220 vss 0
C258 vss.n221 vss 0
C259 vss.n222 vss 0
C260 vss.n223 vss 0.01321f
C261 vss.n224 vss 0.01776f
C262 vss.n225 vss 0.01776f
C263 vss.n226 vss 0
C264 vss.n227 vss 0
C265 vss.n228 vss 0
C266 vss.n229 vss 0
C267 vss.n230 vss 0
C268 vss.n231 vss 0.01776f
C269 vss.n232 vss 0.01776f
C270 vss.n233 vss 0.01776f
C271 vss.n234 vss 0
C272 vss.n235 vss 0
C273 vss.n236 vss 0
C274 vss.n237 vss 0
C275 vss.n238 vss 0.00197f
C276 vss.n239 vss 0
C277 vss.n240 vss 0.0016f
C278 vss.n241 vss 0.01699f
C279 vss.n242 vss 0.0016f
C280 vss.n243 vss 0
C281 vss.n244 vss 0.00651f
C282 vss.n245 vss 0.00582f
C283 vss.n246 vss 0.00463f
C284 vss.n247 vss 0.00613f
C285 vss.n248 vss 0.00682f
C286 vss.n249 vss 0
C287 vss.n250 vss 0.00163f
C288 vss.n251 vss 0.02398f
C289 vss.n252 vss 0.00163f
C290 vss.n253 vss 0
C291 vss.n254 vss 0
C292 vss.n255 vss 0.00213f
C293 vss.n256 vss 0.00765f
C294 vss.n257 vss 0.00262f
C295 vss.n258 vss 0.02332f
C296 vss.n259 vss 0.04024f
C297 vss.n260 vss 0.03708f
C298 vss.n261 vss 0.00262f
C299 vss.n262 vss 0.00463f
C300 vss.n263 vss 0.00537f
C301 vss.n264 vss 0.00457f
C302 vdd.n0 vss 0.01382f
C303 vdd.n1 vss 0.02309f
C304 vdd.n2 vss 0.00452f
C305 vdd.n3 vss 0.00742f
C306 vdd.n4 vss 0.00742f
C307 vdd.n5 vss 0.0045f
C308 vdd.n6 vss 0.00153f
C309 vdd.n7 vss 0.00503f
C310 vdd.n8 vss 0.00503f
C311 vdd.n9 vss 0.00153f
C312 vdd.n10 vss 0.0045f
C313 vdd.n11 vss 0.04176f
C314 vdd.n12 vss 0.06465f
C315 vdd.n13 vss 0.04176f
C316 vdd.n14 vss 0.00452f
C317 vdd.n15 vss 0.00303f
C318 vdd.n16 vss 0.0671f
C319 vdd.n17 vss 0.01176f
C320 vdd.n18 vss 0.01993f
C321 vdd.n19 vss 0.00151f
C322 vdd.n20 vss 0.00393f
C323 vdd.n21 vss 0.00188f
C324 vdd.n22 vss 0.00136f
C325 vdd.n23 vss 0.06879f
C326 vdd.n24 vss 0.00153f
C327 vdd.n25 vss 0.04678f
C328 vdd.n26 vss 0.00136f
C329 vdd.n27 vss 0.00188f
C330 vdd.n28 vss 0.00455f
C331 vdd.n30 vss 0.00626f
C332 vdd.n31 vss 0.00391f
C333 vdd.n32 vss 0.00153f
C334 vdd.n33 vss 0.00455f
C335 vdd.n34 vss 0.00188f
C336 vdd.n35 vss 0.00188f
C337 vdd.n36 vss 0.00188f
C338 vdd.n37 vss 0.00136f
C339 vdd.n39 vss 0.00391f
C340 vdd.n40 vss 0.00626f
C341 vdd.n41 vss 0.00393f
C342 vdd.n42 vss 0.04678f
C343 vdd.n44 vss 0.00136f
C344 vdd.n45 vss 0.00188f
C345 vdd.n46 vss 0.00151f
C346 vdd.n47 vss 0.06055f
C347 vdd.n48 vss 0.07115f
C348 vdd.n49 vss 0.01176f
C349 vdd.n50 vss 0.01993f
C350 vdd.n51 vss 0.00151f
C351 vdd.n52 vss 0.00393f
C352 vdd.n53 vss 0.00188f
C353 vdd.n54 vss 0.00136f
C354 vdd.n55 vss 0.06879f
C355 vdd.n56 vss 0.00153f
C356 vdd.n57 vss 0.04678f
C357 vdd.n58 vss 0.00136f
C358 vdd.n59 vss 0.00188f
C359 vdd.n60 vss 0.00455f
C360 vdd.n62 vss 0.00626f
C361 vdd.n63 vss 0.00391f
C362 vdd.n64 vss 0.00153f
C363 vdd.n65 vss 0.00455f
C364 vdd.n66 vss 0.00188f
C365 vdd.n67 vss 0.00188f
C366 vdd.n68 vss 0.00188f
C367 vdd.n69 vss 0.00136f
C368 vdd.n71 vss 0.00391f
C369 vdd.n72 vss 0.00626f
C370 vdd.n73 vss 0.00393f
C371 vdd.n74 vss 0.04678f
C372 vdd.n76 vss 0.00136f
C373 vdd.n77 vss 0.00188f
C374 vdd.n78 vss 0.00151f
C375 vdd.n79 vss 0.06055f
C376 vdd.n80 vss 0.06493f
C377 vdd.n81 vss 0.01382f
C378 vdd.n82 vss 0.02309f
C379 vdd.n83 vss 0.00452f
C380 vdd.n84 vss 0.00742f
C381 vdd.n85 vss 0.04176f
C382 vdd.n86 vss 0.0045f
C383 vdd.n87 vss 0.00153f
C384 vdd.n88 vss 0.00503f
C385 vdd.n89 vss 0.00503f
C386 vdd.n90 vss 0.00153f
C387 vdd.n91 vss 0.0045f
C388 vdd.n92 vss 0.00742f
C389 vdd.n93 vss 0.06465f
C390 vdd.n94 vss 0.04176f
C391 vdd.n95 vss 0.00452f
C392 vdd.n96 vss 0.00303f
C393 vdd.n97 vss 0.0671f
C394 vdd.n98 vss 0.01176f
C395 vdd.n99 vss 0.01993f
C396 vdd.n100 vss 0.00151f
C397 vdd.n101 vss 0.00393f
C398 vdd.n102 vss 0.00188f
C399 vdd.n103 vss 0.00136f
C400 vdd.n104 vss 0.06879f
C401 vdd.n105 vss 0.00153f
C402 vdd.n106 vss 0.04678f
C403 vdd.n107 vss 0.00136f
C404 vdd.n108 vss 0.00188f
C405 vdd.n109 vss 0.00455f
C406 vdd.n111 vss 0.00626f
C407 vdd.n112 vss 0.00391f
C408 vdd.n113 vss 0.00153f
C409 vdd.n114 vss 0.00455f
C410 vdd.n115 vss 0.00188f
C411 vdd.n116 vss 0.00188f
C412 vdd.n117 vss 0.00188f
C413 vdd.n118 vss 0.00136f
C414 vdd.n120 vss 0.00391f
C415 vdd.n121 vss 0.00626f
C416 vdd.n122 vss 0.00393f
C417 vdd.n123 vss 0.04678f
C418 vdd.n125 vss 0.00136f
C419 vdd.n126 vss 0.00188f
C420 vdd.n127 vss 0.00151f
C421 vdd.n128 vss 0.06055f
C422 vdd.n129 vss 0.07115f
C423 vdd.n130 vss 0.01176f
C424 vdd.n131 vss 0.01993f
C425 vdd.n132 vss 0.00151f
C426 vdd.n133 vss 0.00393f
C427 vdd.n134 vss 0.00188f
C428 vdd.n135 vss 0.00136f
C429 vdd.n136 vss 0.06879f
C430 vdd.n137 vss 0.00153f
C431 vdd.n138 vss 0.04678f
C432 vdd.n139 vss 0.00136f
C433 vdd.n140 vss 0.00188f
C434 vdd.n141 vss 0.00455f
C435 vdd.n143 vss 0.00626f
C436 vdd.n144 vss 0.00391f
C437 vdd.n145 vss 0.00153f
C438 vdd.n146 vss 0.00455f
C439 vdd.n147 vss 0.00188f
C440 vdd.n148 vss 0.00188f
C441 vdd.n149 vss 0.00188f
C442 vdd.n150 vss 0.00136f
C443 vdd.n152 vss 0.00391f
C444 vdd.n153 vss 0.00626f
C445 vdd.n154 vss 0.00393f
C446 vdd.n155 vss 0.04678f
C447 vdd.n157 vss 0.00136f
C448 vdd.n158 vss 0.00188f
C449 vdd.n159 vss 0.00151f
C450 vdd.n160 vss 0.06055f
C451 vdd.n161 vss 0.06493f
C452 vdd.n162 vss 0.01094f
C453 vdd.n163 vss 0.01808f
C454 vdd.n164 vss 0.00386f
C455 vdd.n165 vss 0.0062f
C456 vdd.n166 vss 0.0062f
C457 vdd.n167 vss 0.00385f
C458 vdd.n168 vss 0.00153f
C459 vdd.n169 vss 0.00486f
C460 vdd.n170 vss 0.00486f
C461 vdd.n171 vss 0.00153f
C462 vdd.n172 vss 0.00385f
C463 vdd.n173 vss 0.03397f
C464 vdd.n174 vss 0.04909f
C465 vdd.n175 vss 0.03397f
C466 vdd.n176 vss 0.00386f
C467 vdd.n177 vss 0.00303f
C468 vdd.n178 vss 0.04692f
C469 vdd.n179 vss 0.05267f
C470 Vin.n0 vss 0.21052f
C471 Vin_neg.n0 vss 0.22376f
C472 xm9_0/a_n50_n339# vss -0.80418f
C473 Vin_neg vss 0.21872f
C474 Iex_2_i vss 0.10153f
C475 Iex_4_i vss 0.10683f
C476 Vin vss 0.22854f
C477 xm9_0/a_28_n131# vss -0.38374f
C478 vdd vss -12.07419f
C479 xm3_0/a_28_n281# vss -1.41189f
C480 Iex_1_i vss 0.09145f
C481 xm4_0/a_28_n281# vss -2.00697f
.ends
