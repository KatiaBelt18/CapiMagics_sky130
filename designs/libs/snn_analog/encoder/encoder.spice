* NGSPICE file created from encoder.ext - technology: sky130A

.subckt xm5 w_n524_n528# a_n264_n93# a_186_n93# a_n186_n290#
X0 a_186_n93# a_n186_n290# a_n264_n93# w_n524_n528# sky130_fd_pr__pfet_01v8 ad=0.3627 pd=2.64 as=0.3627 ps=2.64 w=0.93 l=1.86
.ends

.subckt xm3 a_n33_n396# w_n366_n635# a_n106_n200# a_28_n200#
X0 a_28_n200# a_n33_n396# a_n106_n200# w_n366_n635# sky130_fd_pr__pfet_01v8 ad=0.78 pd=4.78 as=0.78 ps=4.78 w=2 l=0.28
.ends

.subckt xm11 w_n366_n485# a_n106_n50# a_n33_n246# a_28_n50#
X0 a_28_n50# a_n33_n246# a_n106_n50# w_n366_n485# sky130_fd_pr__pfet_01v8 ad=0.195 pd=1.78 as=0.195 ps=1.78 w=0.5 l=0.28
.ends

.subckt xm1 a_n1078_n50# a_n1292_n439# a_1000_n50# a_n1000_n246#
X0 a_1000_n50# a_n1000_n246# a_n1078_n50# a_n1292_n439# sky130_fd_pr__nfet_01v8 ad=0.195 pd=1.78 as=0.195 ps=1.78 w=0.5 l=10
.ends

.subckt xm8 w_n524_n528# a_n264_n93# a_186_n93# a_n186_n290#
X0 a_186_n93# a_n186_n290# a_n264_n93# w_n524_n528# sky130_fd_pr__pfet_01v8 ad=0.3627 pd=2.64 as=0.3627 ps=2.64 w=0.93 l=1.86
.ends

.subckt xm6 w_n524_n528# a_n264_n93# a_186_n93# a_n186_n290#
X0 a_186_n93# a_n186_n290# a_n264_n93# w_n524_n528# sky130_fd_pr__pfet_01v8 ad=0.3627 pd=2.64 as=0.3627 ps=2.64 w=0.93 l=1.86
.ends

.subckt xm4 a_n33_n396# w_n366_n635# a_n106_n200# a_28_n200#
X0 a_28_n200# a_n33_n396# a_n106_n200# w_n366_n635# sky130_fd_pr__pfet_01v8 ad=0.78 pd=4.78 as=0.78 ps=4.78 w=2 l=0.28
.ends

.subckt xm2 a_n1078_n50# a_n1292_n439# a_1000_n50# a_n1000_n246#
X0 a_1000_n50# a_n1000_n246# a_n1078_n50# a_n1292_n439# sky130_fd_pr__nfet_01v8 ad=0.195 pd=1.78 as=0.195 ps=1.78 w=0.5 l=10
.ends

.subckt xm10 a_n320_n439# a_n106_n50# a_n33_n246# a_28_n50#
X0 a_28_n50# a_n33_n246# a_n106_n50# a_n320_n439# sky130_fd_pr__nfet_01v8 ad=0.195 pd=1.78 as=0.195 ps=1.78 w=0.5 l=0.28
.ends

.subckt xm9 a_n320_n439# a_n106_n50# a_n33_n246# a_28_n50#
X0 a_28_n50# a_n33_n246# a_n106_n50# a_n320_n439# sky130_fd_pr__nfet_01v8 ad=0.195 pd=1.78 as=0.195 ps=1.78 w=0.5 l=0.28
.ends

.subckt xm7 w_n524_n528# a_n264_n93# a_186_n93# a_n186_n290#
X0 a_186_n93# a_n186_n290# a_n264_n93# w_n524_n528# sky130_fd_pr__pfet_01v8 ad=0.3627 pd=2.64 as=0.3627 ps=2.64 w=0.93 l=1.86
.ends

.subckt encoder Vdd Vss Iex_2_i Iex_1_i Iex_3_i Iex_4_i Vin_neg Vin
Xxm5_0 Vdd Vdd Iex_2_i xm3_0/a_28_n200# xm5
Xxm3_0 xm3_0/a_28_n200# Vdd Vdd xm3_0/a_28_n200# xm3
Xxm11_0 Vdd Vdd xm11_0/a_28_n50# xm11_0/a_28_n50# xm11
Xxm1_0 xm9_0/a_28_n50# Vss xm3_0/a_28_n200# Vin xm1
Xxm8_0 Vdd Vdd Iex_1_i xm3_0/a_28_n200# xm8
Xxm6_0 Vdd Vdd Iex_4_i xm4_0/a_28_n200# xm6
Xxm4_0 xm4_0/a_28_n200# Vdd Vdd xm4_0/a_28_n200# xm4
Xxm2_0 xm9_0/a_28_n50# Vss xm4_0/a_28_n200# Vin_neg xm2
Xxm10_0 Vss Vss xm11_0/a_28_n50# xm11_0/a_28_n50# xm10
Xxm9_0 Vss Vss xm11_0/a_28_n50# xm9_0/a_28_n50# xm9
Xxm7_0 Vdd Vdd Iex_3_i xm4_0/a_28_n200# xm7
.ends
