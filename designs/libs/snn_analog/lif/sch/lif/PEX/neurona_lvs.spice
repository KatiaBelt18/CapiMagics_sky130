* NGSPICE file created from neurona_lvs.ext - technology: gf180mcuD

.subckt m1 a_n178_n131# a_n50_n339# w_n444_n560# a_28_n131# VSUBS
X0 a_28_n131# a_n50_n339# a_n178_n131# w_n444_n560# pfet_03v3 ad=0.375p pd=2.5u as=0.375p ps=2.5u w=0.5u l=0.28u
C0 a_28_n131# w_n444_n560# 0.48499f
C1 a_n178_n131# a_n50_n339# 0.02611f
C2 a_n50_n339# w_n444_n560# 0.39308f
C3 a_28_n131# a_n50_n339# 0.01004f
C4 a_n178_n131# w_n444_n560# 0.22952f
C5 a_28_n131# a_n178_n131# 0.34063f
C6 a_28_n131# VSUBS 0.04441f
C7 a_n178_n131# VSUBS 0.04328f
C8 a_n50_n339# VSUBS 0.04859f
C9 w_n444_n560# VSUBS 3.73985f
.ends

.subckt m8 a_n178_n131# a_n50_n339# a_n388_n504# a_28_n131#
X0 a_28_n131# a_n50_n339# a_n178_n131# a_n388_n504# nfet_03v3 ad=0.375p pd=2.5u as=0.375p ps=2.5u w=0.5u l=0.28u
C0 a_28_n131# a_n178_n131# 0.34063f
C1 a_n178_n131# a_n50_n339# 0.02611f
C2 a_28_n131# a_n50_n339# 0.01004f
C3 a_28_n131# a_n388_n504# 0.52938f
C4 a_n178_n131# a_n388_n504# 0.27279f
C5 a_n50_n339# a_n388_n504# 0.44167f
.ends

.subckt cap m4_n2800_n500# m4_n2920_n620# VSUBS
X0 m4_n2800_n500# m4_n2920_n620# cap_mim_2f0_m4m5_noshield c_width=28u c_length=5u
C0 m4_n2800_n500# m4_n2920_n620# 0.8316f
C1 m4_n2800_n500# VSUBS 2.87627f
C2 m4_n2920_n620# VSUBS 2.30522f
.ends

.subckt m4 a_n178_n131# a_n50_n339# a_n388_n504# a_28_n131#
X0 a_28_n131# a_n50_n339# a_n178_n131# a_n388_n504# nfet_03v3 ad=0.375p pd=2.5u as=0.375p ps=2.5u w=0.5u l=0.28u
C0 a_28_n131# a_n178_n131# 0.34063f
C1 a_n178_n131# a_n50_n339# 0.02611f
C2 a_28_n131# a_n50_n339# 0.01004f
C3 a_28_n131# a_n388_n504# 0.52938f
C4 a_n178_n131# a_n388_n504# 0.27279f
C5 a_n50_n339# a_n388_n504# 0.44167f
.ends

.subckt m2 a_n178_n131# a_n50_n339# a_n388_n504# a_28_n131#
X0 a_28_n131# a_n50_n339# a_n178_n131# a_n388_n504# nfet_03v3 ad=0.375p pd=2.5u as=0.375p ps=2.5u w=0.5u l=0.28u
C0 a_28_n131# a_n178_n131# 0.34063f
C1 a_n178_n131# a_n50_n339# 0.02611f
C2 a_28_n131# a_n50_n339# 0.01004f
C3 a_28_n131# a_n388_n504# 0.52938f
C4 a_n178_n131# a_n388_n504# 0.27279f
C5 a_n50_n339# a_n388_n504# 0.44167f
.ends

.subckt m7 a_n178_n131# a_n50_n339# w_n444_n560# a_28_n131# VSUBS
X0 a_28_n131# a_n50_n339# a_n178_n131# w_n444_n560# pfet_03v3 ad=0.375p pd=2.5u as=0.375p ps=2.5u w=0.5u l=0.28u
C0 a_28_n131# w_n444_n560# 0.48499f
C1 a_n178_n131# a_n50_n339# 0.02611f
C2 a_n50_n339# w_n444_n560# 0.39308f
C3 a_28_n131# a_n50_n339# 0.01004f
C4 a_n178_n131# w_n444_n560# 0.22952f
C5 a_28_n131# a_n178_n131# 0.34063f
C6 a_28_n131# VSUBS 0.04441f
C7 a_n178_n131# VSUBS 0.04328f
C8 a_n50_n339# VSUBS 0.04859f
C9 w_n444_n560# VSUBS 3.73985f
.ends

.subckt m5 a_n5000_n519# a_n5120_n311# a_n5330_n683# a_5000_n311#
X0 a_5000_n311# a_n5000_n519# a_n5120_n311# a_n5330_n683# nfet_03v3 ad=1.38p pd=5.8u as=1.38p ps=5.8u w=2.3u l=50u
C0 a_5000_n311# a_n5120_n311# 4.41467f
C1 a_n5120_n311# a_n5000_n519# 1.8049f
C2 a_5000_n311# a_n5000_n519# 0.22856f
C3 a_5000_n311# a_n5330_n683# 5.37377f
C4 a_n5120_n311# a_n5330_n683# 1.24677f
C5 a_n5000_n519# a_n5330_n683# 21.8141f
.ends

.subckt m3 a_n178_n131# a_n50_n339# w_n444_n560# a_28_n131# VSUBS
X0 a_28_n131# a_n50_n339# a_n178_n131# w_n444_n560# pfet_03v3 ad=0.375p pd=2.5u as=0.375p ps=2.5u w=0.5u l=0.28u
C0 a_28_n131# w_n444_n560# 0.48499f
C1 a_n178_n131# a_n50_n339# 0.02611f
C2 a_n50_n339# w_n444_n560# 0.39308f
C3 a_28_n131# a_n50_n339# 0.01004f
C4 a_n178_n131# w_n444_n560# 0.22952f
C5 a_28_n131# a_n178_n131# 0.34063f
C6 a_28_n131# VSUBS 0.04441f
C7 a_n178_n131# VSUBS 0.04328f
C8 a_n50_n339# VSUBS 0.04859f
C9 w_n444_n560# VSUBS 3.73985f
.ends

.subckt neurona_layout Iin vdd vss spike spike_neg
Xm1_0 vdd Iin vdd spike_neg vss m1
Xm8_0 vss spike_neg vss spike m8
Xcap_0 Iin vss vss cap
Xm4_0 vss spike_neg vss m4_0/a_28_n131# m4
Xm2_0 vss Iin vss spike_neg m2
Xm7_0 vdd spike_neg vdd spike vss m7
Xm5_0 m4_0/a_28_n131# vss vss Iin m5
Xm3_0 vdd spike_neg vdd m4_0/a_28_n131# vss m3
R0 spike_neg.n5 spike_neg.n0 48.4901
R1 spike_neg.n3 spike_neg.n1 48.4901
R2 spike_neg.n5 spike_neg.n4 36.7469
R3 spike_neg.n3 spike_neg.n2 36.7469
R4 spike_neg spike_neg.n5 33.3293
R5 spike_neg.n5 spike_neg.n3 1.0697
R6 Iin.n3 Iin.n2 43.3961
R7 Iin.n3 Iin.n1 41.8859
R8 Iin.n4 Iin.n0 19.3816
R9 Iin Iin.n4 9.6431
R10 Iin.n4 Iin.n3 4.5005
R11 vdd.n13 vdd.n12 528.52
R12 vdd.n12 vdd.n4 528.52
R13 vdd.n30 vdd.n29 528.52
R14 vdd.n29 vdd.n28 528.52
R15 vdd.n48 vdd.n47 528.52
R16 vdd.n47 vdd.n46 528.52
R17 vdd.n11 vdd.n2 61.6005
R18 vdd.n11 vdd.n10 61.6005
R19 vdd.n5 vdd.n3 61.6005
R20 vdd.n14 vdd.n3 61.6005
R21 vdd.n31 vdd.n20 61.6005
R22 vdd.n27 vdd.n20 61.6005
R23 vdd.n22 vdd.n21 61.6005
R24 vdd.n21 vdd.n19 61.6005
R25 vdd.n49 vdd.n38 61.6005
R26 vdd.n45 vdd.n38 61.6005
R27 vdd.n40 vdd.n39 61.6005
R28 vdd.n39 vdd.n37 61.6005
R29 vdd vdd.n52 15.5255
R30 vdd.n15 vdd.n14 6.37187
R31 vdd.n15 vdd.n2 6.37187
R32 vdd.n32 vdd.n31 6.37187
R33 vdd.n32 vdd.n19 6.37187
R34 vdd.n50 vdd.n49 6.37187
R35 vdd.n50 vdd.n37 6.37187
R36 vdd.n10 vdd.n9 6.3005
R37 vdd.n6 vdd.n5 6.3005
R38 vdd.n27 vdd.n26 6.3005
R39 vdd.n23 vdd.n22 6.3005
R40 vdd.n45 vdd.n44 6.3005
R41 vdd.n41 vdd.n40 6.3005
R42 vdd.n7 vdd.n1 5.19561
R43 vdd.n8 vdd.n0 5.19561
R44 vdd.n24 vdd.n18 5.19561
R45 vdd.n25 vdd.n17 5.19561
R46 vdd.n42 vdd.n36 5.19561
R47 vdd.n43 vdd.n35 5.19561
R48 vdd.n16 vdd.n1 4.98321
R49 vdd.n33 vdd.n18 4.98321
R50 vdd.n51 vdd.n36 4.98321
R51 vdd.n16 vdd.n0 4.97539
R52 vdd.n33 vdd.n17 4.97539
R53 vdd.n51 vdd.n35 4.97539
R54 vdd.n9 vdd.n8 4.5005
R55 vdd.n7 vdd.n6 4.5005
R56 vdd.n26 vdd.n25 4.5005
R57 vdd.n24 vdd.n23 4.5005
R58 vdd.n44 vdd.n43 4.5005
R59 vdd.n42 vdd.n41 4.5005
R60 vdd.n10 vdd.n4 3.31679
R61 vdd.n5 vdd.n4 3.31679
R62 vdd.n13 vdd.n2 3.31679
R63 vdd.n14 vdd.n13 3.31679
R64 vdd.n28 vdd.n27 3.31679
R65 vdd.n28 vdd.n22 3.31679
R66 vdd.n30 vdd.n19 3.31679
R67 vdd.n31 vdd.n30 3.31679
R68 vdd.n46 vdd.n45 3.31679
R69 vdd.n46 vdd.n40 3.31679
R70 vdd.n48 vdd.n37 3.31679
R71 vdd.n49 vdd.n48 3.31679
R72 vdd.n16 vdd.n15 2.21557
R73 vdd.n33 vdd.n32 2.21557
R74 vdd.n51 vdd.n50 2.21557
R75 vdd.n11 vdd.n0 0.9005
R76 vdd.n12 vdd.n11 0.9005
R77 vdd.n3 vdd.n1 0.9005
R78 vdd.n12 vdd.n3 0.9005
R79 vdd.n20 vdd.n17 0.9005
R80 vdd.n29 vdd.n20 0.9005
R81 vdd.n21 vdd.n18 0.9005
R82 vdd.n29 vdd.n21 0.9005
R83 vdd.n38 vdd.n35 0.9005
R84 vdd.n47 vdd.n38 0.9005
R85 vdd.n39 vdd.n36 0.9005
R86 vdd.n47 vdd.n39 0.9005
R87 vdd.n34 vdd.n16 0.613685
R88 vdd.n52 vdd.n34 0.5009
R89 vdd.n9 vdd.n6 0.1445
R90 vdd.n8 vdd.n7 0.1445
R91 vdd.n26 vdd.n23 0.1445
R92 vdd.n25 vdd.n24 0.1445
R93 vdd.n44 vdd.n41 0.1445
R94 vdd.n43 vdd.n42 0.1445
R95 vdd.n34 vdd.n33 0.113285
R96 vdd.n52 vdd.n51 0.113285
R97 vss.n460 vss.n56 14388.8
R98 vss.n477 vss.n56 12133.3
R99 vss.n502 vss.n26 12133.3
R100 vss.n56 vss.n26 4826.25
R101 vss.n420 vss.n26 4216.88
R102 vss.n460 vss.n70 225.671
R103 vss.n430 vss.n5 142.155
R104 vss.n504 vss.n503 142.155
R105 vss.n495 vss.n36 142.155
R106 vss.n484 vss.n46 142.155
R107 vss.n476 vss.n475 142.155
R108 vss.n511 vss.n510 136.823
R109 vss.n93 vss.n8 136.823
R110 vss.n83 vss.n67 126.162
R111 vss.n469 vss.n468 126.162
R112 vss.n478 vss.n54 119.055
R113 vss.n83 vss.n59 115.501
R114 vss.n501 vss.n28 108.394
R115 vss.n502 vss.n501 106.617
R116 vss.n93 vss.n23 104.84
R117 vss.n478 vss.n477 95.9546
R118 vss.n430 vss.n99 94.1776
R119 vss.n240 vss.n231 93.2239
R120 vss.n248 vss.n231 93.2239
R121 vss.n248 vss.n225 93.2239
R122 vss.n256 vss.n225 93.2239
R123 vss.n256 vss.n219 93.2239
R124 vss.n264 vss.n219 93.2239
R125 vss.n264 vss.n213 93.2239
R126 vss.n272 vss.n213 93.2239
R127 vss.n272 vss.n207 93.2239
R128 vss.n280 vss.n207 93.2239
R129 vss.n280 vss.n201 93.2239
R130 vss.n288 vss.n201 93.2239
R131 vss.n288 vss.n195 93.2239
R132 vss.n296 vss.n195 93.2239
R133 vss.n296 vss.n189 93.2239
R134 vss.n304 vss.n189 93.2239
R135 vss.n304 vss.n183 93.2239
R136 vss.n312 vss.n183 93.2239
R137 vss.n312 vss.n177 93.2239
R138 vss.n320 vss.n177 93.2239
R139 vss.n320 vss.n171 93.2239
R140 vss.n328 vss.n171 93.2239
R141 vss.n328 vss.n165 93.2239
R142 vss.n336 vss.n165 93.2239
R143 vss.n336 vss.n159 93.2239
R144 vss.n344 vss.n159 93.2239
R145 vss.n344 vss.n153 93.2239
R146 vss.n352 vss.n153 93.2239
R147 vss.n352 vss.n147 93.2239
R148 vss.n360 vss.n147 93.2239
R149 vss.n360 vss.n141 93.2239
R150 vss.n368 vss.n141 93.2239
R151 vss.n368 vss.n135 93.2239
R152 vss.n376 vss.n135 93.2239
R153 vss.n376 vss.n129 93.2239
R154 vss.n384 vss.n129 93.2239
R155 vss.n384 vss.n123 93.2239
R156 vss.n392 vss.n123 93.2239
R157 vss.n392 vss.n117 93.2239
R158 vss.n400 vss.n117 93.2239
R159 vss.n400 vss.n111 93.2239
R160 vss.n408 vss.n111 93.2239
R161 vss.n408 vss.n105 93.2239
R162 vss.n421 vss.n105 93.2239
R163 vss.n241 vss.n235 84.0977
R164 vss.n461 vss.n66 84.0977
R165 vss.n461 vss.n459 84.0977
R166 vss.n494 vss.n39 76.4084
R167 vss.n485 vss.n484 76.4084
R168 vss.n421 vss.n420 71.0833
R169 vss.n71 vss.n69 68.4449
R170 vss.n467 vss.n71 68.4449
R171 vss.n79 vss.n72 68.4449
R172 vss.n79 vss.n78 68.4449
R173 vss.n486 vss.n44 68.4449
R174 vss.n44 vss.n41 68.4449
R175 vss.n493 vss.n40 68.4449
R176 vss.n40 vss.n38 68.4449
R177 vss.n6 vss.n4 68.4449
R178 vss.n512 vss.n4 68.4449
R179 vss.n22 vss.n21 68.4449
R180 vss.n22 vss.n3 68.4449
R181 vss.n495 vss.n494 65.7468
R182 vss.n485 vss.n39 65.7468
R183 vss.n239 vss.n235 52.5135
R184 vss.n419 vss.n99 47.9775
R185 vss.n477 vss.n476 46.2006
R186 vss.n504 vss.n23 37.316
R187 vss.n503 vss.n502 35.539
R188 vss.n420 vss.n419 33.7621
R189 vss.n36 vss.n28 33.7621
R190 vss.n475 vss.n59 26.6544
R191 vss.n54 vss.n46 23.1006
R192 vss.n469 vss.n67 15.9928
R193 vss.n468 vss.n70 15.9928
R194 vss.n78 vss.n69 15.5561
R195 vss.n486 vss.n38 15.5561
R196 vss.n241 vss.n232 15.5561
R197 vss.n247 vss.n232 15.5561
R198 vss.n247 vss.n224 15.5561
R199 vss.n257 vss.n224 15.5561
R200 vss.n257 vss.n220 15.5561
R201 vss.n263 vss.n220 15.5561
R202 vss.n263 vss.n212 15.5561
R203 vss.n273 vss.n212 15.5561
R204 vss.n273 vss.n208 15.5561
R205 vss.n279 vss.n208 15.5561
R206 vss.n279 vss.n200 15.5561
R207 vss.n289 vss.n200 15.5561
R208 vss.n289 vss.n196 15.5561
R209 vss.n295 vss.n196 15.5561
R210 vss.n295 vss.n188 15.5561
R211 vss.n305 vss.n188 15.5561
R212 vss.n305 vss.n184 15.5561
R213 vss.n311 vss.n184 15.5561
R214 vss.n311 vss.n176 15.5561
R215 vss.n321 vss.n176 15.5561
R216 vss.n321 vss.n172 15.5561
R217 vss.n327 vss.n172 15.5561
R218 vss.n327 vss.n164 15.5561
R219 vss.n337 vss.n164 15.5561
R220 vss.n337 vss.n160 15.5561
R221 vss.n343 vss.n160 15.5561
R222 vss.n343 vss.n152 15.5561
R223 vss.n353 vss.n152 15.5561
R224 vss.n353 vss.n148 15.5561
R225 vss.n359 vss.n148 15.5561
R226 vss.n359 vss.n140 15.5561
R227 vss.n369 vss.n140 15.5561
R228 vss.n369 vss.n136 15.5561
R229 vss.n375 vss.n136 15.5561
R230 vss.n375 vss.n128 15.5561
R231 vss.n385 vss.n128 15.5561
R232 vss.n385 vss.n124 15.5561
R233 vss.n391 vss.n124 15.5561
R234 vss.n391 vss.n116 15.5561
R235 vss.n401 vss.n116 15.5561
R236 vss.n401 vss.n112 15.5561
R237 vss.n407 vss.n112 15.5561
R238 vss.n407 vss.n104 15.5561
R239 vss.n422 vss.n104 15.5561
R240 vss.n422 vss.n100 15.5561
R241 vss.n429 vss.n100 15.5561
R242 vss.n429 vss.n9 15.5561
R243 vss.n509 vss.n9 15.5561
R244 vss.n509 vss.n10 15.5561
R245 vss.n505 vss.n10 15.5561
R246 vss.n505 vss.n16 15.5561
R247 vss.n500 vss.n16 15.5561
R248 vss.n500 vss.n29 15.5561
R249 vss.n496 vss.n29 15.5561
R250 vss.n496 vss.n35 15.5561
R251 vss.n483 vss.n35 15.5561
R252 vss.n483 vss.n47 15.5561
R253 vss.n479 vss.n47 15.5561
R254 vss.n479 vss.n53 15.5561
R255 vss.n474 vss.n53 15.5561
R256 vss.n474 vss.n60 15.5561
R257 vss.n470 vss.n60 15.5561
R258 vss.n470 vss.n66 15.5561
R259 vss.n238 vss.n230 15.5561
R260 vss.n249 vss.n230 15.5561
R261 vss.n249 vss.n226 15.5561
R262 vss.n255 vss.n226 15.5561
R263 vss.n255 vss.n218 15.5561
R264 vss.n265 vss.n218 15.5561
R265 vss.n265 vss.n214 15.5561
R266 vss.n271 vss.n214 15.5561
R267 vss.n271 vss.n206 15.5561
R268 vss.n281 vss.n206 15.5561
R269 vss.n281 vss.n202 15.5561
R270 vss.n287 vss.n202 15.5561
R271 vss.n287 vss.n194 15.5561
R272 vss.n297 vss.n194 15.5561
R273 vss.n297 vss.n190 15.5561
R274 vss.n303 vss.n190 15.5561
R275 vss.n303 vss.n182 15.5561
R276 vss.n313 vss.n182 15.5561
R277 vss.n313 vss.n178 15.5561
R278 vss.n319 vss.n178 15.5561
R279 vss.n319 vss.n170 15.5561
R280 vss.n329 vss.n170 15.5561
R281 vss.n329 vss.n166 15.5561
R282 vss.n335 vss.n166 15.5561
R283 vss.n335 vss.n158 15.5561
R284 vss.n345 vss.n158 15.5561
R285 vss.n345 vss.n154 15.5561
R286 vss.n351 vss.n154 15.5561
R287 vss.n351 vss.n146 15.5561
R288 vss.n361 vss.n146 15.5561
R289 vss.n361 vss.n142 15.5561
R290 vss.n367 vss.n142 15.5561
R291 vss.n367 vss.n134 15.5561
R292 vss.n377 vss.n134 15.5561
R293 vss.n377 vss.n130 15.5561
R294 vss.n383 vss.n130 15.5561
R295 vss.n383 vss.n122 15.5561
R296 vss.n393 vss.n122 15.5561
R297 vss.n393 vss.n118 15.5561
R298 vss.n399 vss.n118 15.5561
R299 vss.n399 vss.n110 15.5561
R300 vss.n409 vss.n110 15.5561
R301 vss.n409 vss.n106 15.5561
R302 vss.n418 vss.n106 15.5561
R303 vss.n418 vss.n98 15.5561
R304 vss.n431 vss.n98 15.5561
R305 vss.n432 vss.n431 15.5561
R306 vss.n432 vss.n7 15.5561
R307 vss.n94 vss.n7 15.5561
R308 vss.n94 vss.n24 15.5561
R309 vss.n25 vss.n24 15.5561
R310 vss.n27 vss.n25 15.5561
R311 vss.n90 vss.n27 15.5561
R312 vss.n90 vss.n37 15.5561
R313 vss.n445 vss.n37 15.5561
R314 vss.n445 vss.n45 15.5561
R315 vss.n87 vss.n45 15.5561
R316 vss.n87 vss.n55 15.5561
R317 vss.n57 vss.n55 15.5561
R318 vss.n58 vss.n57 15.5561
R319 vss.n84 vss.n58 15.5561
R320 vss.n84 vss.n68 15.5561
R321 vss.n459 vss.n68 15.5561
R322 vss.n21 vss.n6 15.5561
R323 vss.n464 vss.n463 11.1326
R324 vss vss.n515 7.73878
R325 vss.n243 vss.n234 5.35452
R326 vss.n236 vss.n234 5.35452
R327 vss.n462 vss.n82 5.3467
R328 vss.n511 vss.n5 5.33128
R329 vss.n510 vss.n8 5.33128
R330 vss.n418 vss.n417 5.2005
R331 vss.n421 vss.n418 5.2005
R332 vss.n107 vss.n106 5.2005
R333 vss.n106 vss.n105 5.2005
R334 vss.n410 vss.n409 5.2005
R335 vss.n409 vss.n408 5.2005
R336 vss.n110 vss.n109 5.2005
R337 vss.n111 vss.n110 5.2005
R338 vss.n399 vss.n398 5.2005
R339 vss.n400 vss.n399 5.2005
R340 vss.n119 vss.n118 5.2005
R341 vss.n118 vss.n117 5.2005
R342 vss.n394 vss.n393 5.2005
R343 vss.n393 vss.n392 5.2005
R344 vss.n122 vss.n121 5.2005
R345 vss.n123 vss.n122 5.2005
R346 vss.n383 vss.n382 5.2005
R347 vss.n384 vss.n383 5.2005
R348 vss.n131 vss.n130 5.2005
R349 vss.n130 vss.n129 5.2005
R350 vss.n378 vss.n377 5.2005
R351 vss.n377 vss.n376 5.2005
R352 vss.n134 vss.n133 5.2005
R353 vss.n135 vss.n134 5.2005
R354 vss.n367 vss.n366 5.2005
R355 vss.n368 vss.n367 5.2005
R356 vss.n143 vss.n142 5.2005
R357 vss.n142 vss.n141 5.2005
R358 vss.n362 vss.n361 5.2005
R359 vss.n361 vss.n360 5.2005
R360 vss.n146 vss.n145 5.2005
R361 vss.n147 vss.n146 5.2005
R362 vss.n351 vss.n350 5.2005
R363 vss.n352 vss.n351 5.2005
R364 vss.n155 vss.n154 5.2005
R365 vss.n154 vss.n153 5.2005
R366 vss.n346 vss.n345 5.2005
R367 vss.n345 vss.n344 5.2005
R368 vss.n158 vss.n157 5.2005
R369 vss.n159 vss.n158 5.2005
R370 vss.n335 vss.n334 5.2005
R371 vss.n336 vss.n335 5.2005
R372 vss.n167 vss.n166 5.2005
R373 vss.n166 vss.n165 5.2005
R374 vss.n330 vss.n329 5.2005
R375 vss.n329 vss.n328 5.2005
R376 vss.n170 vss.n169 5.2005
R377 vss.n171 vss.n170 5.2005
R378 vss.n319 vss.n318 5.2005
R379 vss.n320 vss.n319 5.2005
R380 vss.n179 vss.n178 5.2005
R381 vss.n178 vss.n177 5.2005
R382 vss.n314 vss.n313 5.2005
R383 vss.n313 vss.n312 5.2005
R384 vss.n182 vss.n181 5.2005
R385 vss.n183 vss.n182 5.2005
R386 vss.n303 vss.n302 5.2005
R387 vss.n304 vss.n303 5.2005
R388 vss.n191 vss.n190 5.2005
R389 vss.n190 vss.n189 5.2005
R390 vss.n298 vss.n297 5.2005
R391 vss.n297 vss.n296 5.2005
R392 vss.n194 vss.n193 5.2005
R393 vss.n195 vss.n194 5.2005
R394 vss.n287 vss.n286 5.2005
R395 vss.n288 vss.n287 5.2005
R396 vss.n203 vss.n202 5.2005
R397 vss.n202 vss.n201 5.2005
R398 vss.n282 vss.n281 5.2005
R399 vss.n281 vss.n280 5.2005
R400 vss.n206 vss.n205 5.2005
R401 vss.n207 vss.n206 5.2005
R402 vss.n271 vss.n270 5.2005
R403 vss.n272 vss.n271 5.2005
R404 vss.n215 vss.n214 5.2005
R405 vss.n214 vss.n213 5.2005
R406 vss.n266 vss.n265 5.2005
R407 vss.n265 vss.n264 5.2005
R408 vss.n218 vss.n217 5.2005
R409 vss.n219 vss.n218 5.2005
R410 vss.n255 vss.n254 5.2005
R411 vss.n256 vss.n255 5.2005
R412 vss.n227 vss.n226 5.2005
R413 vss.n226 vss.n225 5.2005
R414 vss.n250 vss.n249 5.2005
R415 vss.n249 vss.n248 5.2005
R416 vss.n230 vss.n229 5.2005
R417 vss.n231 vss.n230 5.2005
R418 vss.n238 vss.n237 5.2005
R419 vss.n242 vss.n241 5.2005
R420 vss.n241 vss.n240 5.2005
R421 vss.n233 vss.n232 5.2005
R422 vss.n232 vss.n231 5.2005
R423 vss.n247 vss.n246 5.2005
R424 vss.n248 vss.n247 5.2005
R425 vss.n224 vss.n223 5.2005
R426 vss.n225 vss.n224 5.2005
R427 vss.n258 vss.n257 5.2005
R428 vss.n257 vss.n256 5.2005
R429 vss.n221 vss.n220 5.2005
R430 vss.n220 vss.n219 5.2005
R431 vss.n263 vss.n262 5.2005
R432 vss.n264 vss.n263 5.2005
R433 vss.n212 vss.n211 5.2005
R434 vss.n213 vss.n212 5.2005
R435 vss.n274 vss.n273 5.2005
R436 vss.n273 vss.n272 5.2005
R437 vss.n209 vss.n208 5.2005
R438 vss.n208 vss.n207 5.2005
R439 vss.n279 vss.n278 5.2005
R440 vss.n280 vss.n279 5.2005
R441 vss.n200 vss.n199 5.2005
R442 vss.n201 vss.n200 5.2005
R443 vss.n290 vss.n289 5.2005
R444 vss.n289 vss.n288 5.2005
R445 vss.n197 vss.n196 5.2005
R446 vss.n196 vss.n195 5.2005
R447 vss.n295 vss.n294 5.2005
R448 vss.n296 vss.n295 5.2005
R449 vss.n188 vss.n187 5.2005
R450 vss.n189 vss.n188 5.2005
R451 vss.n306 vss.n305 5.2005
R452 vss.n305 vss.n304 5.2005
R453 vss.n185 vss.n184 5.2005
R454 vss.n184 vss.n183 5.2005
R455 vss.n311 vss.n310 5.2005
R456 vss.n312 vss.n311 5.2005
R457 vss.n176 vss.n175 5.2005
R458 vss.n177 vss.n176 5.2005
R459 vss.n322 vss.n321 5.2005
R460 vss.n321 vss.n320 5.2005
R461 vss.n173 vss.n172 5.2005
R462 vss.n172 vss.n171 5.2005
R463 vss.n327 vss.n326 5.2005
R464 vss.n328 vss.n327 5.2005
R465 vss.n164 vss.n163 5.2005
R466 vss.n165 vss.n164 5.2005
R467 vss.n338 vss.n337 5.2005
R468 vss.n337 vss.n336 5.2005
R469 vss.n161 vss.n160 5.2005
R470 vss.n160 vss.n159 5.2005
R471 vss.n343 vss.n342 5.2005
R472 vss.n344 vss.n343 5.2005
R473 vss.n152 vss.n151 5.2005
R474 vss.n153 vss.n152 5.2005
R475 vss.n354 vss.n353 5.2005
R476 vss.n353 vss.n352 5.2005
R477 vss.n149 vss.n148 5.2005
R478 vss.n148 vss.n147 5.2005
R479 vss.n359 vss.n358 5.2005
R480 vss.n360 vss.n359 5.2005
R481 vss.n140 vss.n139 5.2005
R482 vss.n141 vss.n140 5.2005
R483 vss.n370 vss.n369 5.2005
R484 vss.n369 vss.n368 5.2005
R485 vss.n137 vss.n136 5.2005
R486 vss.n136 vss.n135 5.2005
R487 vss.n375 vss.n374 5.2005
R488 vss.n376 vss.n375 5.2005
R489 vss.n128 vss.n127 5.2005
R490 vss.n129 vss.n128 5.2005
R491 vss.n386 vss.n385 5.2005
R492 vss.n385 vss.n384 5.2005
R493 vss.n125 vss.n124 5.2005
R494 vss.n124 vss.n123 5.2005
R495 vss.n391 vss.n390 5.2005
R496 vss.n392 vss.n391 5.2005
R497 vss.n116 vss.n115 5.2005
R498 vss.n117 vss.n116 5.2005
R499 vss.n402 vss.n401 5.2005
R500 vss.n401 vss.n400 5.2005
R501 vss.n113 vss.n112 5.2005
R502 vss.n112 vss.n111 5.2005
R503 vss.n407 vss.n406 5.2005
R504 vss.n408 vss.n407 5.2005
R505 vss.n104 vss.n103 5.2005
R506 vss.n105 vss.n104 5.2005
R507 vss.n423 vss.n422 5.2005
R508 vss.n422 vss.n421 5.2005
R509 vss.n487 vss.n486 5.2005
R510 vss.n486 vss.n485 5.2005
R511 vss.n488 vss.n38 5.2005
R512 vss.n494 vss.n38 5.2005
R513 vss.n485 vss.n41 5.2005
R514 vss.n494 vss.n493 5.2005
R515 vss.n76 vss.n69 5.2005
R516 vss.n468 vss.n69 5.2005
R517 vss.n78 vss.n77 5.2005
R518 vss.n78 vss.n67 5.2005
R519 vss.n468 vss.n467 5.2005
R520 vss.n72 vss.n67 5.2005
R521 vss.n459 vss.n458 5.2005
R522 vss.n459 vss.n70 5.2005
R523 vss.n457 vss.n68 5.2005
R524 vss.n469 vss.n68 5.2005
R525 vss.n85 vss.n84 5.2005
R526 vss.n84 vss.n83 5.2005
R527 vss.n453 vss.n58 5.2005
R528 vss.n475 vss.n58 5.2005
R529 vss.n452 vss.n57 5.2005
R530 vss.n476 vss.n57 5.2005
R531 vss.n451 vss.n55 5.2005
R532 vss.n478 vss.n55 5.2005
R533 vss.n88 vss.n87 5.2005
R534 vss.n87 vss.n46 5.2005
R535 vss.n447 vss.n45 5.2005
R536 vss.n484 vss.n45 5.2005
R537 vss.n446 vss.n445 5.2005
R538 vss.n445 vss.n39 5.2005
R539 vss.n444 vss.n37 5.2005
R540 vss.n495 vss.n37 5.2005
R541 vss.n91 vss.n90 5.2005
R542 vss.n90 vss.n36 5.2005
R543 vss.n440 vss.n27 5.2005
R544 vss.n501 vss.n27 5.2005
R545 vss.n439 vss.n25 5.2005
R546 vss.n503 vss.n25 5.2005
R547 vss.n438 vss.n24 5.2005
R548 vss.n504 vss.n24 5.2005
R549 vss.n95 vss.n94 5.2005
R550 vss.n94 vss.n93 5.2005
R551 vss.n434 vss.n7 5.2005
R552 vss.n510 vss.n7 5.2005
R553 vss.n433 vss.n432 5.2005
R554 vss.n432 vss.n5 5.2005
R555 vss.n431 vss.n97 5.2005
R556 vss.n431 vss.n430 5.2005
R557 vss.n416 vss.n98 5.2005
R558 vss.n419 vss.n98 5.2005
R559 vss.n101 vss.n100 5.2005
R560 vss.n419 vss.n100 5.2005
R561 vss.n429 vss.n428 5.2005
R562 vss.n430 vss.n429 5.2005
R563 vss.n11 vss.n9 5.2005
R564 vss.n9 vss.n5 5.2005
R565 vss.n509 vss.n508 5.2005
R566 vss.n510 vss.n509 5.2005
R567 vss.n507 vss.n10 5.2005
R568 vss.n93 vss.n10 5.2005
R569 vss.n506 vss.n505 5.2005
R570 vss.n505 vss.n504 5.2005
R571 vss.n16 vss.n15 5.2005
R572 vss.n503 vss.n16 5.2005
R573 vss.n500 vss.n499 5.2005
R574 vss.n501 vss.n500 5.2005
R575 vss.n498 vss.n29 5.2005
R576 vss.n36 vss.n29 5.2005
R577 vss.n497 vss.n496 5.2005
R578 vss.n496 vss.n495 5.2005
R579 vss.n35 vss.n34 5.2005
R580 vss.n39 vss.n35 5.2005
R581 vss.n483 vss.n482 5.2005
R582 vss.n484 vss.n483 5.2005
R583 vss.n481 vss.n47 5.2005
R584 vss.n47 vss.n46 5.2005
R585 vss.n480 vss.n479 5.2005
R586 vss.n479 vss.n478 5.2005
R587 vss.n53 vss.n52 5.2005
R588 vss.n476 vss.n53 5.2005
R589 vss.n474 vss.n473 5.2005
R590 vss.n475 vss.n474 5.2005
R591 vss.n472 vss.n60 5.2005
R592 vss.n83 vss.n60 5.2005
R593 vss.n471 vss.n470 5.2005
R594 vss.n470 vss.n469 5.2005
R595 vss.n66 vss.n65 5.2005
R596 vss.n70 vss.n66 5.2005
R597 vss.n21 vss.n20 5.2005
R598 vss.n21 vss.n8 5.2005
R599 vss.n17 vss.n6 5.2005
R600 vss.n511 vss.n6 5.2005
R601 vss.n8 vss.n3 5.2005
R602 vss.n512 vss.n511 5.2005
R603 vss.n490 vss.n489 5.19561
R604 vss.n80 vss.n74 5.19561
R605 vss.n18 vss.n2 5.19561
R606 vss.n43 vss.n42 5.18779
R607 vss.n75 vss.n73 5.18779
R608 vss.n19 vss.n1 5.18779
R609 vss.n463 vss.n462 5.12952
R610 vss.n491 vss.n490 4.98321
R611 vss.n491 vss.n42 4.98321
R612 vss.n465 vss.n80 4.98321
R613 vss.n465 vss.n73 4.98321
R614 vss.n514 vss.n1 4.98321
R615 vss.n514 vss.n2 4.98321
R616 vss.n243 vss.n242 4.5005
R617 vss.n244 vss.n233 4.5005
R618 vss.n246 vss.n245 4.5005
R619 vss.n223 vss.n222 4.5005
R620 vss.n259 vss.n258 4.5005
R621 vss.n260 vss.n221 4.5005
R622 vss.n262 vss.n261 4.5005
R623 vss.n211 vss.n210 4.5005
R624 vss.n275 vss.n274 4.5005
R625 vss.n276 vss.n209 4.5005
R626 vss.n278 vss.n277 4.5005
R627 vss.n199 vss.n198 4.5005
R628 vss.n291 vss.n290 4.5005
R629 vss.n292 vss.n197 4.5005
R630 vss.n294 vss.n293 4.5005
R631 vss.n187 vss.n186 4.5005
R632 vss.n307 vss.n306 4.5005
R633 vss.n308 vss.n185 4.5005
R634 vss.n310 vss.n309 4.5005
R635 vss.n175 vss.n174 4.5005
R636 vss.n323 vss.n322 4.5005
R637 vss.n324 vss.n173 4.5005
R638 vss.n326 vss.n325 4.5005
R639 vss.n163 vss.n162 4.5005
R640 vss.n339 vss.n338 4.5005
R641 vss.n340 vss.n161 4.5005
R642 vss.n342 vss.n341 4.5005
R643 vss.n151 vss.n150 4.5005
R644 vss.n355 vss.n354 4.5005
R645 vss.n356 vss.n149 4.5005
R646 vss.n358 vss.n357 4.5005
R647 vss.n139 vss.n138 4.5005
R648 vss.n371 vss.n370 4.5005
R649 vss.n372 vss.n137 4.5005
R650 vss.n374 vss.n373 4.5005
R651 vss.n127 vss.n126 4.5005
R652 vss.n387 vss.n386 4.5005
R653 vss.n388 vss.n125 4.5005
R654 vss.n390 vss.n389 4.5005
R655 vss.n115 vss.n114 4.5005
R656 vss.n403 vss.n402 4.5005
R657 vss.n404 vss.n113 4.5005
R658 vss.n406 vss.n405 4.5005
R659 vss.n103 vss.n102 4.5005
R660 vss.n424 vss.n423 4.5005
R661 vss.n425 vss.n101 4.5005
R662 vss.n428 vss.n427 4.5005
R663 vss.n426 vss.n11 4.5005
R664 vss.n508 vss.n12 4.5005
R665 vss.n507 vss.n13 4.5005
R666 vss.n506 vss.n14 4.5005
R667 vss.n30 vss.n15 4.5005
R668 vss.n499 vss.n31 4.5005
R669 vss.n498 vss.n32 4.5005
R670 vss.n497 vss.n33 4.5005
R671 vss.n48 vss.n34 4.5005
R672 vss.n482 vss.n49 4.5005
R673 vss.n481 vss.n50 4.5005
R674 vss.n480 vss.n51 4.5005
R675 vss.n61 vss.n52 4.5005
R676 vss.n473 vss.n62 4.5005
R677 vss.n472 vss.n63 4.5005
R678 vss.n471 vss.n64 4.5005
R679 vss.n82 vss.n65 4.5005
R680 vss.n487 vss.n43 4.5005
R681 vss.n489 vss.n488 4.5005
R682 vss.n76 vss.n75 4.5005
R683 vss.n77 vss.n74 4.5005
R684 vss.n229 vss.n228 4.5005
R685 vss.n251 vss.n250 4.5005
R686 vss.n252 vss.n227 4.5005
R687 vss.n254 vss.n253 4.5005
R688 vss.n217 vss.n216 4.5005
R689 vss.n267 vss.n266 4.5005
R690 vss.n268 vss.n215 4.5005
R691 vss.n270 vss.n269 4.5005
R692 vss.n205 vss.n204 4.5005
R693 vss.n283 vss.n282 4.5005
R694 vss.n284 vss.n203 4.5005
R695 vss.n286 vss.n285 4.5005
R696 vss.n193 vss.n192 4.5005
R697 vss.n299 vss.n298 4.5005
R698 vss.n300 vss.n191 4.5005
R699 vss.n302 vss.n301 4.5005
R700 vss.n181 vss.n180 4.5005
R701 vss.n315 vss.n314 4.5005
R702 vss.n316 vss.n179 4.5005
R703 vss.n318 vss.n317 4.5005
R704 vss.n169 vss.n168 4.5005
R705 vss.n331 vss.n330 4.5005
R706 vss.n332 vss.n167 4.5005
R707 vss.n334 vss.n333 4.5005
R708 vss.n157 vss.n156 4.5005
R709 vss.n347 vss.n346 4.5005
R710 vss.n348 vss.n155 4.5005
R711 vss.n350 vss.n349 4.5005
R712 vss.n145 vss.n144 4.5005
R713 vss.n363 vss.n362 4.5005
R714 vss.n364 vss.n143 4.5005
R715 vss.n366 vss.n365 4.5005
R716 vss.n133 vss.n132 4.5005
R717 vss.n379 vss.n378 4.5005
R718 vss.n380 vss.n131 4.5005
R719 vss.n382 vss.n381 4.5005
R720 vss.n121 vss.n120 4.5005
R721 vss.n395 vss.n394 4.5005
R722 vss.n396 vss.n119 4.5005
R723 vss.n398 vss.n397 4.5005
R724 vss.n109 vss.n108 4.5005
R725 vss.n411 vss.n410 4.5005
R726 vss.n412 vss.n107 4.5005
R727 vss.n417 vss.n413 4.5005
R728 vss.n416 vss.n415 4.5005
R729 vss.n414 vss.n97 4.5005
R730 vss.n433 vss.n96 4.5005
R731 vss.n435 vss.n434 4.5005
R732 vss.n436 vss.n95 4.5005
R733 vss.n438 vss.n437 4.5005
R734 vss.n439 vss.n92 4.5005
R735 vss.n441 vss.n440 4.5005
R736 vss.n442 vss.n91 4.5005
R737 vss.n444 vss.n443 4.5005
R738 vss.n446 vss.n89 4.5005
R739 vss.n448 vss.n447 4.5005
R740 vss.n449 vss.n88 4.5005
R741 vss.n451 vss.n450 4.5005
R742 vss.n452 vss.n86 4.5005
R743 vss.n454 vss.n453 4.5005
R744 vss.n455 vss.n85 4.5005
R745 vss.n457 vss.n456 4.5005
R746 vss.n458 vss.n81 4.5005
R747 vss.n237 vss.n236 4.5005
R748 vss.n20 vss.n19 4.5005
R749 vss.n18 vss.n17 4.5005
R750 vss.n492 vss.n491 3.28078
R751 vss.n466 vss.n465 3.28078
R752 vss.n514 vss.n513 3.28078
R753 vss.n240 vss.n239 3.24802
R754 vss.n466 vss.n72 3.14293
R755 vss.n493 vss.n492 3.14293
R756 vss.n492 vss.n41 3.14293
R757 vss.n467 vss.n466 3.14293
R758 vss.n513 vss.n512 3.14293
R759 vss.n513 vss.n3 3.14293
R760 vss.n239 vss.n238 1.84026
R761 vss.n490 vss.n40 0.743357
R762 vss.n40 vss.n28 0.743357
R763 vss.n44 vss.n42 0.743357
R764 vss.n54 vss.n44 0.743357
R765 vss.n80 vss.n79 0.743357
R766 vss.n79 vss.n59 0.743357
R767 vss.n73 vss.n71 0.743357
R768 vss.n460 vss.n71 0.743357
R769 vss.n4 vss.n2 0.743357
R770 vss.n99 vss.n4 0.743357
R771 vss.n22 vss.n1 0.743357
R772 vss.n23 vss.n22 0.743357
R773 vss.n515 vss.n0 0.5009
R774 vss.n464 vss.n0 0.5009
R775 vss.n235 vss.n234 0.473227
R776 vss.n462 vss.n461 0.473227
R777 vss.n461 vss.n460 0.473227
R778 vss.n463 vss.n81 0.2255
R779 vss.n237 vss.n229 0.1445
R780 vss.n250 vss.n229 0.1445
R781 vss.n250 vss.n227 0.1445
R782 vss.n254 vss.n227 0.1445
R783 vss.n254 vss.n217 0.1445
R784 vss.n266 vss.n217 0.1445
R785 vss.n266 vss.n215 0.1445
R786 vss.n270 vss.n215 0.1445
R787 vss.n270 vss.n205 0.1445
R788 vss.n282 vss.n205 0.1445
R789 vss.n282 vss.n203 0.1445
R790 vss.n286 vss.n203 0.1445
R791 vss.n286 vss.n193 0.1445
R792 vss.n298 vss.n193 0.1445
R793 vss.n298 vss.n191 0.1445
R794 vss.n302 vss.n191 0.1445
R795 vss.n302 vss.n181 0.1445
R796 vss.n314 vss.n181 0.1445
R797 vss.n314 vss.n179 0.1445
R798 vss.n318 vss.n179 0.1445
R799 vss.n318 vss.n169 0.1445
R800 vss.n330 vss.n169 0.1445
R801 vss.n330 vss.n167 0.1445
R802 vss.n334 vss.n167 0.1445
R803 vss.n334 vss.n157 0.1445
R804 vss.n346 vss.n157 0.1445
R805 vss.n346 vss.n155 0.1445
R806 vss.n350 vss.n155 0.1445
R807 vss.n350 vss.n145 0.1445
R808 vss.n362 vss.n145 0.1445
R809 vss.n362 vss.n143 0.1445
R810 vss.n366 vss.n143 0.1445
R811 vss.n366 vss.n133 0.1445
R812 vss.n378 vss.n133 0.1445
R813 vss.n378 vss.n131 0.1445
R814 vss.n382 vss.n131 0.1445
R815 vss.n382 vss.n121 0.1445
R816 vss.n394 vss.n121 0.1445
R817 vss.n394 vss.n119 0.1445
R818 vss.n398 vss.n119 0.1445
R819 vss.n398 vss.n109 0.1445
R820 vss.n410 vss.n109 0.1445
R821 vss.n410 vss.n107 0.1445
R822 vss.n417 vss.n107 0.1445
R823 vss.n417 vss.n416 0.1445
R824 vss.n416 vss.n97 0.1445
R825 vss.n433 vss.n97 0.1445
R826 vss.n434 vss.n433 0.1445
R827 vss.n434 vss.n95 0.1445
R828 vss.n438 vss.n95 0.1445
R829 vss.n439 vss.n438 0.1445
R830 vss.n440 vss.n439 0.1445
R831 vss.n440 vss.n91 0.1445
R832 vss.n444 vss.n91 0.1445
R833 vss.n446 vss.n444 0.1445
R834 vss.n447 vss.n446 0.1445
R835 vss.n447 vss.n88 0.1445
R836 vss.n451 vss.n88 0.1445
R837 vss.n452 vss.n451 0.1445
R838 vss.n453 vss.n452 0.1445
R839 vss.n453 vss.n85 0.1445
R840 vss.n457 vss.n85 0.1445
R841 vss.n458 vss.n457 0.1445
R842 vss.n242 vss.n233 0.1445
R843 vss.n246 vss.n233 0.1445
R844 vss.n246 vss.n223 0.1445
R845 vss.n258 vss.n223 0.1445
R846 vss.n258 vss.n221 0.1445
R847 vss.n262 vss.n221 0.1445
R848 vss.n262 vss.n211 0.1445
R849 vss.n274 vss.n211 0.1445
R850 vss.n274 vss.n209 0.1445
R851 vss.n278 vss.n209 0.1445
R852 vss.n278 vss.n199 0.1445
R853 vss.n290 vss.n199 0.1445
R854 vss.n290 vss.n197 0.1445
R855 vss.n294 vss.n197 0.1445
R856 vss.n294 vss.n187 0.1445
R857 vss.n306 vss.n187 0.1445
R858 vss.n306 vss.n185 0.1445
R859 vss.n310 vss.n185 0.1445
R860 vss.n310 vss.n175 0.1445
R861 vss.n322 vss.n175 0.1445
R862 vss.n322 vss.n173 0.1445
R863 vss.n326 vss.n173 0.1445
R864 vss.n326 vss.n163 0.1445
R865 vss.n338 vss.n163 0.1445
R866 vss.n338 vss.n161 0.1445
R867 vss.n342 vss.n161 0.1445
R868 vss.n342 vss.n151 0.1445
R869 vss.n354 vss.n151 0.1445
R870 vss.n354 vss.n149 0.1445
R871 vss.n358 vss.n149 0.1445
R872 vss.n358 vss.n139 0.1445
R873 vss.n370 vss.n139 0.1445
R874 vss.n370 vss.n137 0.1445
R875 vss.n374 vss.n137 0.1445
R876 vss.n374 vss.n127 0.1445
R877 vss.n386 vss.n127 0.1445
R878 vss.n386 vss.n125 0.1445
R879 vss.n390 vss.n125 0.1445
R880 vss.n390 vss.n115 0.1445
R881 vss.n402 vss.n115 0.1445
R882 vss.n402 vss.n113 0.1445
R883 vss.n406 vss.n113 0.1445
R884 vss.n406 vss.n103 0.1445
R885 vss.n423 vss.n103 0.1445
R886 vss.n423 vss.n101 0.1445
R887 vss.n428 vss.n101 0.1445
R888 vss.n428 vss.n11 0.1445
R889 vss.n508 vss.n11 0.1445
R890 vss.n508 vss.n507 0.1445
R891 vss.n507 vss.n506 0.1445
R892 vss.n506 vss.n15 0.1445
R893 vss.n499 vss.n15 0.1445
R894 vss.n499 vss.n498 0.1445
R895 vss.n498 vss.n497 0.1445
R896 vss.n497 vss.n34 0.1445
R897 vss.n482 vss.n34 0.1445
R898 vss.n482 vss.n481 0.1445
R899 vss.n481 vss.n480 0.1445
R900 vss.n480 vss.n52 0.1445
R901 vss.n473 vss.n52 0.1445
R902 vss.n473 vss.n472 0.1445
R903 vss.n472 vss.n471 0.1445
R904 vss.n471 vss.n65 0.1445
R905 vss.n244 vss.n243 0.1445
R906 vss.n245 vss.n244 0.1445
R907 vss.n245 vss.n222 0.1445
R908 vss.n259 vss.n222 0.1445
R909 vss.n260 vss.n259 0.1445
R910 vss.n261 vss.n260 0.1445
R911 vss.n261 vss.n210 0.1445
R912 vss.n275 vss.n210 0.1445
R913 vss.n276 vss.n275 0.1445
R914 vss.n277 vss.n276 0.1445
R915 vss.n277 vss.n198 0.1445
R916 vss.n291 vss.n198 0.1445
R917 vss.n292 vss.n291 0.1445
R918 vss.n293 vss.n292 0.1445
R919 vss.n293 vss.n186 0.1445
R920 vss.n307 vss.n186 0.1445
R921 vss.n308 vss.n307 0.1445
R922 vss.n309 vss.n308 0.1445
R923 vss.n309 vss.n174 0.1445
R924 vss.n323 vss.n174 0.1445
R925 vss.n324 vss.n323 0.1445
R926 vss.n325 vss.n324 0.1445
R927 vss.n325 vss.n162 0.1445
R928 vss.n339 vss.n162 0.1445
R929 vss.n340 vss.n339 0.1445
R930 vss.n341 vss.n340 0.1445
R931 vss.n341 vss.n150 0.1445
R932 vss.n355 vss.n150 0.1445
R933 vss.n356 vss.n355 0.1445
R934 vss.n357 vss.n356 0.1445
R935 vss.n357 vss.n138 0.1445
R936 vss.n371 vss.n138 0.1445
R937 vss.n372 vss.n371 0.1445
R938 vss.n373 vss.n372 0.1445
R939 vss.n373 vss.n126 0.1445
R940 vss.n387 vss.n126 0.1445
R941 vss.n388 vss.n387 0.1445
R942 vss.n389 vss.n388 0.1445
R943 vss.n389 vss.n114 0.1445
R944 vss.n403 vss.n114 0.1445
R945 vss.n404 vss.n403 0.1445
R946 vss.n405 vss.n404 0.1445
R947 vss.n405 vss.n102 0.1445
R948 vss.n424 vss.n102 0.1445
R949 vss.n425 vss.n424 0.1445
R950 vss.n427 vss.n425 0.1445
R951 vss.n427 vss.n426 0.1445
R952 vss.n426 vss.n12 0.1445
R953 vss.n13 vss.n12 0.1445
R954 vss.n14 vss.n13 0.1445
R955 vss.n30 vss.n14 0.1445
R956 vss.n31 vss.n30 0.1445
R957 vss.n32 vss.n31 0.1445
R958 vss.n33 vss.n32 0.1445
R959 vss.n48 vss.n33 0.1445
R960 vss.n49 vss.n48 0.1445
R961 vss.n50 vss.n49 0.1445
R962 vss.n51 vss.n50 0.1445
R963 vss.n61 vss.n51 0.1445
R964 vss.n62 vss.n61 0.1445
R965 vss.n63 vss.n62 0.1445
R966 vss.n64 vss.n63 0.1445
R967 vss.n82 vss.n64 0.1445
R968 vss.n488 vss.n487 0.1445
R969 vss.n489 vss.n43 0.1445
R970 vss.n77 vss.n76 0.1445
R971 vss.n75 vss.n74 0.1445
R972 vss.n236 vss.n228 0.1445
R973 vss.n251 vss.n228 0.1445
R974 vss.n252 vss.n251 0.1445
R975 vss.n253 vss.n252 0.1445
R976 vss.n253 vss.n216 0.1445
R977 vss.n267 vss.n216 0.1445
R978 vss.n268 vss.n267 0.1445
R979 vss.n269 vss.n268 0.1445
R980 vss.n269 vss.n204 0.1445
R981 vss.n283 vss.n204 0.1445
R982 vss.n284 vss.n283 0.1445
R983 vss.n285 vss.n284 0.1445
R984 vss.n285 vss.n192 0.1445
R985 vss.n299 vss.n192 0.1445
R986 vss.n300 vss.n299 0.1445
R987 vss.n301 vss.n300 0.1445
R988 vss.n301 vss.n180 0.1445
R989 vss.n315 vss.n180 0.1445
R990 vss.n316 vss.n315 0.1445
R991 vss.n317 vss.n316 0.1445
R992 vss.n317 vss.n168 0.1445
R993 vss.n331 vss.n168 0.1445
R994 vss.n332 vss.n331 0.1445
R995 vss.n333 vss.n332 0.1445
R996 vss.n333 vss.n156 0.1445
R997 vss.n347 vss.n156 0.1445
R998 vss.n348 vss.n347 0.1445
R999 vss.n349 vss.n348 0.1445
R1000 vss.n349 vss.n144 0.1445
R1001 vss.n363 vss.n144 0.1445
R1002 vss.n364 vss.n363 0.1445
R1003 vss.n365 vss.n364 0.1445
R1004 vss.n365 vss.n132 0.1445
R1005 vss.n379 vss.n132 0.1445
R1006 vss.n380 vss.n379 0.1445
R1007 vss.n381 vss.n380 0.1445
R1008 vss.n381 vss.n120 0.1445
R1009 vss.n395 vss.n120 0.1445
R1010 vss.n396 vss.n395 0.1445
R1011 vss.n397 vss.n396 0.1445
R1012 vss.n397 vss.n108 0.1445
R1013 vss.n411 vss.n108 0.1445
R1014 vss.n412 vss.n411 0.1445
R1015 vss.n413 vss.n412 0.1445
R1016 vss.n415 vss.n413 0.1445
R1017 vss.n415 vss.n414 0.1445
R1018 vss.n414 vss.n96 0.1445
R1019 vss.n435 vss.n96 0.1445
R1020 vss.n436 vss.n435 0.1445
R1021 vss.n437 vss.n436 0.1445
R1022 vss.n437 vss.n92 0.1445
R1023 vss.n441 vss.n92 0.1445
R1024 vss.n442 vss.n441 0.1445
R1025 vss.n443 vss.n442 0.1445
R1026 vss.n443 vss.n89 0.1445
R1027 vss.n448 vss.n89 0.1445
R1028 vss.n449 vss.n448 0.1445
R1029 vss.n450 vss.n449 0.1445
R1030 vss.n450 vss.n86 0.1445
R1031 vss.n454 vss.n86 0.1445
R1032 vss.n455 vss.n454 0.1445
R1033 vss.n456 vss.n455 0.1445
R1034 vss.n456 vss.n81 0.1445
R1035 vss.n20 vss.n17 0.1445
R1036 vss.n19 vss.n18 0.1445
R1037 vss.n491 vss.n0 0.0933481
R1038 vss.n465 vss.n464 0.0933481
R1039 vss.n515 vss.n514 0.0933481
C0 Iin vdd 0.11171f
C1 spike spike_neg 0.81933f
C2 Iin m4_0/a_28_n131# 1.29291f
C3 spike_neg vdd 2.6638f
C4 m4_0/a_28_n131# spike_neg 1.46495f
C5 spike vdd 0.55075f
C6 spike m4_0/a_28_n131# 0.23235f
C7 m4_0/a_28_n131# vdd 0.38291f
C8 Iin spike_neg 0.93387f
C9 spike Iin 0.12445f
C10 vss.n0 vss 0.01017f
C11 vss.n1 vss 0.00536f
C12 vss.n2 vss 0.00322f
C13 vss.n3 vss 0.00114f
C14 vss.n4 vss 0.00183f
C15 vss.n5 vss 0.01053f
C16 vss.n6 vss 0.00113f
C17 vss.n7 vss 0
C18 vss.n8 vss 0.01015f
C19 vss.n9 vss 0
C20 vss.n10 vss 0
C21 vss.n11 vss 0
C22 vss.n12 vss 0
C23 vss.n13 vss 0
C24 vss.n14 vss 0
C25 vss.n15 vss 0
C26 vss.n16 vss 0
C27 vss.n17 vss 0
C28 vss.n18 vss 0.00143f
C29 vss.n19 vss 0.00148f
C30 vss.n20 vss 0
C31 vss.n21 vss 0.00113f
C32 vss.n22 vss 0.00183f
C33 vss.n23 vss 0.01015f
C34 vss.n24 vss 0
C35 vss.n25 vss 0
C36 vss.n26 vss 0.0367f
C37 vss.n27 vss 0
C38 vss.n28 vss 0.01015f
C39 vss.n29 vss 0
C40 vss.n30 vss 0
C41 vss.n31 vss 0
C42 vss.n32 vss 0
C43 vss.n33 vss 0
C44 vss.n34 vss 0
C45 vss.n35 vss 0
C46 vss.n36 vss 0.01256f
C47 vss.n37 vss 0
C48 vss.n38 vss 0.00113f
C49 vss.n39 vss 0.01015f
C50 vss.n40 vss 0.00183f
C51 vss.n41 vss 0.00114f
C52 vss.n42 vss 0.00536f
C53 vss.n43 vss 0.00148f
C54 vss.n44 vss 0.00183f
C55 vss.n45 vss 0
C56 vss.n46 vss 0.0118f
C57 vss.n47 vss 0
C58 vss.n48 vss 0
C59 vss.n49 vss 0
C60 vss.n50 vss 0
C61 vss.n51 vss 0
C62 vss.n52 vss 0
C63 vss.n53 vss 0
C64 vss.n54 vss 0.01015f
C65 vss.n55 vss 0
C66 vss.n56 vss 0.06023f
C67 vss.n57 vss 0
C68 vss.n58 vss 0
C69 vss.n59 vss 0.01015f
C70 vss.n60 vss 0
C71 vss.n61 vss 0
C72 vss.n62 vss 0
C73 vss.n63 vss 0
C74 vss.n64 vss 0
C75 vss.n65 vss 0
C76 vss.n66 vss 0.00134f
C77 vss.n67 vss 0.01015f
C78 vss.n68 vss 0
C79 vss.n69 vss 0.00113f
C80 vss.n70 vss 0.01725f
C81 vss.n71 vss 0.00183f
C82 vss.n72 vss 0.00114f
C83 vss.n73 vss 0.00536f
C84 vss.n74 vss 0.00143f
C85 vss.n75 vss 0.00148f
C86 vss.n76 vss 0
C87 vss.n77 vss 0
C88 vss.n78 vss 0.00113f
C89 vss.n79 vss 0.00183f
C90 vss.n80 vss 0.00322f
C91 vss.n81 vss 0
C92 vss.n82 vss 0.00353f
C93 vss.n83 vss 0.01725f
C94 vss.n84 vss 0
C95 vss.n85 vss 0
C96 vss.n86 vss 0
C97 vss.n87 vss 0
C98 vss.n88 vss 0
C99 vss.n89 vss 0
C100 vss.n90 vss 0
C101 vss.n91 vss 0
C102 vss.n92 vss 0
C103 vss.n93 vss 0.01725f
C104 vss.n94 vss 0
C105 vss.n95 vss 0
C106 vss.n96 vss 0
C107 vss.n97 vss 0
C108 vss.n98 vss 0
C109 vss.n99 vss 0.01015f
C110 vss.n100 vss 0
C111 vss.n101 vss 0
C112 vss.n102 vss 0
C113 vss.n103 vss 0
C114 vss.n104 vss 0
C115 vss.n105 vss 0.03094f
C116 vss.n106 vss 0
C117 vss.n107 vss 0
C118 vss.n108 vss 0
C119 vss.n109 vss 0
C120 vss.n110 vss 0
C121 vss.n111 vss 0.03094f
C122 vss.n112 vss 0
C123 vss.n113 vss 0
C124 vss.n114 vss 0
C125 vss.n115 vss 0
C126 vss.n116 vss 0
C127 vss.n117 vss 0.03094f
C128 vss.n118 vss 0
C129 vss.n119 vss 0
C130 vss.n120 vss 0
C131 vss.n121 vss 0
C132 vss.n122 vss 0
C133 vss.n123 vss 0.03094f
C134 vss.n124 vss 0
C135 vss.n125 vss 0
C136 vss.n126 vss 0
C137 vss.n127 vss 0
C138 vss.n128 vss 0
C139 vss.n129 vss 0.03094f
C140 vss.n130 vss 0
C141 vss.n131 vss 0
C142 vss.n132 vss 0
C143 vss.n133 vss 0
C144 vss.n134 vss 0
C145 vss.n135 vss 0.03094f
C146 vss.n136 vss 0
C147 vss.n137 vss 0
C148 vss.n138 vss 0
C149 vss.n139 vss 0
C150 vss.n140 vss 0
C151 vss.n141 vss 0.03094f
C152 vss.n142 vss 0
C153 vss.n143 vss 0
C154 vss.n144 vss 0
C155 vss.n145 vss 0
C156 vss.n146 vss 0
C157 vss.n147 vss 0.03094f
C158 vss.n148 vss 0
C159 vss.n149 vss 0
C160 vss.n150 vss 0
C161 vss.n151 vss 0
C162 vss.n152 vss 0
C163 vss.n153 vss 0.03094f
C164 vss.n154 vss 0
C165 vss.n155 vss 0
C166 vss.n156 vss 0
C167 vss.n157 vss 0
C168 vss.n158 vss 0
C169 vss.n159 vss 0.03094f
C170 vss.n160 vss 0
C171 vss.n161 vss 0
C172 vss.n162 vss 0
C173 vss.n163 vss 0
C174 vss.n164 vss 0
C175 vss.n165 vss 0.03094f
C176 vss.n166 vss 0
C177 vss.n167 vss 0
C178 vss.n168 vss 0
C179 vss.n169 vss 0
C180 vss.n170 vss 0
C181 vss.n171 vss 0.03094f
C182 vss.n172 vss 0
C183 vss.n173 vss 0
C184 vss.n174 vss 0
C185 vss.n175 vss 0
C186 vss.n176 vss 0
C187 vss.n177 vss 0.03094f
C188 vss.n178 vss 0
C189 vss.n179 vss 0
C190 vss.n180 vss 0
C191 vss.n181 vss 0
C192 vss.n182 vss 0
C193 vss.n183 vss 0.03094f
C194 vss.n184 vss 0
C195 vss.n185 vss 0
C196 vss.n186 vss 0
C197 vss.n187 vss 0
C198 vss.n188 vss 0
C199 vss.n189 vss 0.03094f
C200 vss.n190 vss 0
C201 vss.n191 vss 0
C202 vss.n192 vss 0
C203 vss.n193 vss 0
C204 vss.n194 vss 0
C205 vss.n195 vss 0.03094f
C206 vss.n196 vss 0
C207 vss.n197 vss 0
C208 vss.n198 vss 0
C209 vss.n199 vss 0
C210 vss.n200 vss 0
C211 vss.n201 vss 0.03094f
C212 vss.n202 vss 0
C213 vss.n203 vss 0
C214 vss.n204 vss 0
C215 vss.n205 vss 0
C216 vss.n206 vss 0
C217 vss.n207 vss 0.03094f
C218 vss.n208 vss 0
C219 vss.n209 vss 0
C220 vss.n210 vss 0
C221 vss.n211 vss 0
C222 vss.n212 vss 0
C223 vss.n213 vss 0.03094f
C224 vss.n214 vss 0
C225 vss.n215 vss 0
C226 vss.n216 vss 0
C227 vss.n217 vss 0
C228 vss.n218 vss 0
C229 vss.n219 vss 0.03094f
C230 vss.n220 vss 0
C231 vss.n221 vss 0
C232 vss.n222 vss 0
C233 vss.n223 vss 0
C234 vss.n224 vss 0
C235 vss.n225 vss 0.03094f
C236 vss.n226 vss 0
C237 vss.n227 vss 0
C238 vss.n228 vss 0
C239 vss.n229 vss 0
C240 vss.n230 vss 0
C241 vss.n231 vss 0.03094f
C242 vss.n232 vss 0
C243 vss.n233 vss 0
C244 vss.n234 vss 0.00427f
C245 vss.n235 vss 0.12155f
C246 vss.n236 vss 0.00144f
C247 vss.n237 vss 0
C248 vss.n238 vss 0.00134f
C249 vss.n240 vss 0.04042f
C250 vss.n241 vss 0.00134f
C251 vss.n242 vss 0
C252 vss.n243 vss 0.00144f
C253 vss.n244 vss 0
C254 vss.n245 vss 0
C255 vss.n246 vss 0
C256 vss.n247 vss 0
C257 vss.n248 vss 0.03094f
C258 vss.n249 vss 0
C259 vss.n250 vss 0
C260 vss.n251 vss 0
C261 vss.n252 vss 0
C262 vss.n253 vss 0
C263 vss.n254 vss 0
C264 vss.n255 vss 0
C265 vss.n256 vss 0.03094f
C266 vss.n257 vss 0
C267 vss.n258 vss 0
C268 vss.n259 vss 0
C269 vss.n260 vss 0
C270 vss.n261 vss 0
C271 vss.n262 vss 0
C272 vss.n263 vss 0
C273 vss.n264 vss 0.03094f
C274 vss.n265 vss 0
C275 vss.n266 vss 0
C276 vss.n267 vss 0
C277 vss.n268 vss 0
C278 vss.n269 vss 0
C279 vss.n270 vss 0
C280 vss.n271 vss 0
C281 vss.n272 vss 0.03094f
C282 vss.n273 vss 0
C283 vss.n274 vss 0
C284 vss.n275 vss 0
C285 vss.n276 vss 0
C286 vss.n277 vss 0
C287 vss.n278 vss 0
C288 vss.n279 vss 0
C289 vss.n280 vss 0.03094f
C290 vss.n281 vss 0
C291 vss.n282 vss 0
C292 vss.n283 vss 0
C293 vss.n284 vss 0
C294 vss.n285 vss 0
C295 vss.n286 vss 0
C296 vss.n287 vss 0
C297 vss.n288 vss 0.03094f
C298 vss.n289 vss 0
C299 vss.n290 vss 0
C300 vss.n291 vss 0
C301 vss.n292 vss 0
C302 vss.n293 vss 0
C303 vss.n294 vss 0
C304 vss.n295 vss 0
C305 vss.n296 vss 0.03094f
C306 vss.n297 vss 0
C307 vss.n298 vss 0
C308 vss.n299 vss 0
C309 vss.n300 vss 0
C310 vss.n301 vss 0
C311 vss.n302 vss 0
C312 vss.n303 vss 0
C313 vss.n304 vss 0.03094f
C314 vss.n305 vss 0
C315 vss.n306 vss 0
C316 vss.n307 vss 0
C317 vss.n308 vss 0
C318 vss.n309 vss 0
C319 vss.n310 vss 0
C320 vss.n311 vss 0
C321 vss.n312 vss 0.03094f
C322 vss.n313 vss 0
C323 vss.n314 vss 0
C324 vss.n315 vss 0
C325 vss.n316 vss 0
C326 vss.n317 vss 0
C327 vss.n318 vss 0
C328 vss.n319 vss 0
C329 vss.n320 vss 0.03094f
C330 vss.n321 vss 0
C331 vss.n322 vss 0
C332 vss.n323 vss 0
C333 vss.n324 vss 0
C334 vss.n325 vss 0
C335 vss.n326 vss 0
C336 vss.n327 vss 0
C337 vss.n328 vss 0.03094f
C338 vss.n329 vss 0
C339 vss.n330 vss 0
C340 vss.n331 vss 0
C341 vss.n332 vss 0
C342 vss.n333 vss 0
C343 vss.n334 vss 0
C344 vss.n335 vss 0
C345 vss.n336 vss 0.03094f
C346 vss.n337 vss 0
C347 vss.n338 vss 0
C348 vss.n339 vss 0
C349 vss.n340 vss 0
C350 vss.n341 vss 0
C351 vss.n342 vss 0
C352 vss.n343 vss 0
C353 vss.n344 vss 0.03094f
C354 vss.n345 vss 0
C355 vss.n346 vss 0
C356 vss.n347 vss 0
C357 vss.n348 vss 0
C358 vss.n349 vss 0
C359 vss.n350 vss 0
C360 vss.n351 vss 0
C361 vss.n352 vss 0.03094f
C362 vss.n353 vss 0
C363 vss.n354 vss 0
C364 vss.n355 vss 0
C365 vss.n356 vss 0
C366 vss.n357 vss 0
C367 vss.n358 vss 0
C368 vss.n359 vss 0
C369 vss.n360 vss 0.03094f
C370 vss.n361 vss 0
C371 vss.n362 vss 0
C372 vss.n363 vss 0
C373 vss.n364 vss 0
C374 vss.n365 vss 0
C375 vss.n366 vss 0
C376 vss.n367 vss 0
C377 vss.n368 vss 0.03094f
C378 vss.n369 vss 0
C379 vss.n370 vss 0
C380 vss.n371 vss 0
C381 vss.n372 vss 0
C382 vss.n373 vss 0
C383 vss.n374 vss 0
C384 vss.n375 vss 0
C385 vss.n376 vss 0.03094f
C386 vss.n377 vss 0
C387 vss.n378 vss 0
C388 vss.n379 vss 0
C389 vss.n380 vss 0
C390 vss.n381 vss 0
C391 vss.n382 vss 0
C392 vss.n383 vss 0
C393 vss.n384 vss 0.03094f
C394 vss.n385 vss 0
C395 vss.n386 vss 0
C396 vss.n387 vss 0
C397 vss.n388 vss 0
C398 vss.n389 vss 0
C399 vss.n390 vss 0
C400 vss.n391 vss 0
C401 vss.n392 vss 0.03094f
C402 vss.n393 vss 0
C403 vss.n394 vss 0
C404 vss.n395 vss 0
C405 vss.n396 vss 0
C406 vss.n397 vss 0
C407 vss.n398 vss 0
C408 vss.n399 vss 0
C409 vss.n400 vss 0.03094f
C410 vss.n401 vss 0
C411 vss.n402 vss 0
C412 vss.n403 vss 0
C413 vss.n404 vss 0
C414 vss.n405 vss 0
C415 vss.n406 vss 0
C416 vss.n407 vss 0
C417 vss.n408 vss 0.03094f
C418 vss.n409 vss 0
C419 vss.n410 vss 0
C420 vss.n411 vss 0
C421 vss.n412 vss 0
C422 vss.n413 vss 0
C423 vss.n414 vss 0
C424 vss.n415 vss 0
C425 vss.n416 vss 0
C426 vss.n417 vss 0
C427 vss.n418 vss 0
C428 vss.n419 vss 0.00583f
C429 vss.n420 vss 0.0286f
C430 vss.n421 vss 0.02727f
C431 vss.n422 vss 0
C432 vss.n423 vss 0
C433 vss.n424 vss 0
C434 vss.n425 vss 0
C435 vss.n426 vss 0
C436 vss.n427 vss 0
C437 vss.n428 vss 0
C438 vss.n429 vss 0
C439 vss.n430 vss 0.01687f
C440 vss.n431 vss 0
C441 vss.n432 vss 0
C442 vss.n433 vss 0
C443 vss.n434 vss 0
C444 vss.n435 vss 0
C445 vss.n436 vss 0
C446 vss.n437 vss 0
C447 vss.n438 vss 0
C448 vss.n439 vss 0
C449 vss.n440 vss 0
C450 vss.n441 vss 0
C451 vss.n442 vss 0
C452 vss.n443 vss 0
C453 vss.n444 vss 0
C454 vss.n445 vss 0
C455 vss.n446 vss 0
C456 vss.n447 vss 0
C457 vss.n448 vss 0
C458 vss.n449 vss 0
C459 vss.n450 vss 0
C460 vss.n451 vss 0
C461 vss.n452 vss 0
C462 vss.n453 vss 0
C463 vss.n454 vss 0
C464 vss.n455 vss 0
C465 vss.n456 vss 0
C466 vss.n457 vss 0
C467 vss.n458 vss 0
C468 vss.n459 vss 0.00134f
C469 vss.n460 vss 0.096f
C470 vss.n461 vss 0.00221f
C471 vss.n462 vss 0.03969f
C472 vss.n463 vss 0.00499f
C473 vss.n464 vss 0.0137f
C474 vss.n465 vss 0.00926f
C475 vss.n466 vss 0
C476 vss.n467 vss 0.00114f
C477 vss.n468 vss 0.01015f
C478 vss.n469 vss 0.01015f
C479 vss.n470 vss 0
C480 vss.n471 vss 0
C481 vss.n472 vss 0
C482 vss.n473 vss 0
C483 vss.n474 vss 0
C484 vss.n475 vss 0.01205f
C485 vss.n476 vss 0.01344f
C486 vss.n477 vss 0.01597f
C487 vss.n478 vss 0.01535f
C488 vss.n479 vss 0
C489 vss.n480 vss 0
C490 vss.n481 vss 0
C491 vss.n482 vss 0
C492 vss.n483 vss 0
C493 vss.n484 vss 0.0156f
C494 vss.n485 vss 0.01015f
C495 vss.n486 vss 0.00113f
C496 vss.n487 vss 0
C497 vss.n488 vss 0
C498 vss.n489 vss 0.00143f
C499 vss.n490 vss 0.00322f
C500 vss.n491 vss 0.00926f
C501 vss.n492 vss 0
C502 vss.n493 vss 0.00114f
C503 vss.n494 vss 0.01015f
C504 vss.n495 vss 0.01484f
C505 vss.n496 vss 0
C506 vss.n497 vss 0
C507 vss.n498 vss 0
C508 vss.n499 vss 0
C509 vss.n500 vss 0
C510 vss.n501 vss 0.01535f
C511 vss.n502 vss 0.01597f
C512 vss.n503 vss 0.01268f
C513 vss.n504 vss 0.01281f
C514 vss.n505 vss 0
C515 vss.n506 vss 0
C516 vss.n507 vss 0
C517 vss.n508 vss 0
C518 vss.n509 vss 0
C519 vss.n510 vss 0.01015f
C520 vss.n511 vss 0.01015f
C521 vss.n512 vss 0.00114f
C522 vss.n513 vss 0
C523 vss.n514 vss 0.00926f
C524 vss.n515 vss 0.01912f
C525 vdd.n0 vss 0.02889f
C526 vdd.n1 vss 0.0174f
C527 vdd.n2 vss 0.00615f
C528 vdd.n3 vss 0.00986f
C529 vdd.n4 vss 0.05402f
C530 vdd.n5 vss 0.00612f
C531 vdd.n6 vss 0.00243f
C532 vdd.n7 vss 0.00773f
C533 vdd.n8 vss 0.00773f
C534 vdd.n9 vss 0.00243f
C535 vdd.n10 vss 0.00612f
C536 vdd.n11 vss 0.00986f
C537 vdd.n12 vss 0.07808f
C538 vdd.n13 vss 0.05402f
C539 vdd.n14 vss 0.00615f
C540 vdd.n15 vss 0.00481f
C541 vdd.n16 vss 0.1043f
C542 vdd.n17 vss 0.02889f
C543 vdd.n18 vss 0.0174f
C544 vdd.n19 vss 0.00615f
C545 vdd.n20 vss 0.00986f
C546 vdd.n21 vss 0.00986f
C547 vdd.n22 vss 0.00612f
C548 vdd.n23 vss 0.00243f
C549 vdd.n24 vss 0.00773f
C550 vdd.n25 vss 0.00773f
C551 vdd.n26 vss 0.00243f
C552 vdd.n27 vss 0.00612f
C553 vdd.n28 vss 0.05402f
C554 vdd.n29 vss 0.07808f
C555 vdd.n30 vss 0.05402f
C556 vdd.n31 vss 0.00615f
C557 vdd.n32 vss 0.00481f
C558 vdd.n33 vss 0.05701f
C559 vdd.n34 vss 0.07381f
C560 vdd.n35 vss 0.02889f
C561 vdd.n36 vss 0.0174f
C562 vdd.n37 vss 0.00615f
C563 vdd.n38 vss 0.00986f
C564 vdd.n39 vss 0.00986f
C565 vdd.n40 vss 0.00612f
C566 vdd.n41 vss 0.00243f
C567 vdd.n42 vss 0.00773f
C568 vdd.n43 vss 0.00773f
C569 vdd.n44 vss 0.00243f
C570 vdd.n45 vss 0.00612f
C571 vdd.n46 vss 0.05402f
C572 vdd.n47 vss 0.07808f
C573 vdd.n48 vss 0.05402f
C574 vdd.n49 vss 0.00615f
C575 vdd.n50 vss 0.00481f
C576 vdd.n51 vss 0.05701f
C577 vdd.n52 vss 0.09975f
C578 Iin.n0 vss 1.66677f
C579 Iin.n1 vss 0.00136f
C580 Iin.n2 vss 0.00191f
C581 Iin.n3 vss 0.0308f
C582 Iin.n4 vss 0.08295f
C583 spike_neg.n0 vss 0.00429f
C584 spike_neg.n1 vss 0.00429f
C585 spike_neg.n2 vss 0
C586 spike_neg.n3 vss 0.02909f
C587 spike_neg.n4 vss 0
C588 spike_neg.n5 vss 0.09487f
C589 m4_0/a_28_n131# vss -0.64406f
C590 spike vss -0.15576f
C591 Iin vss 1.36365f
C592 spike_neg vss -2.60699f
C593 vdd vss -4.28565f
.ends
