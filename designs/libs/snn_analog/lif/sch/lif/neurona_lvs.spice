** sch_path: /foss/designs/CapiMagics/sch/lif/neurona_lvs.sch
.subckt neurona_lvs Vdd Vss Iin spike spike_neg
*.PININFO Vdd:B Vss:B Iin:I spike:O spike_neg:O
M1 spike_neg Iin Vdd Vdd pfet_03v3 L=0.28u W=0.22u nf=1
M2 spike_neg Iin Vss Vss nfet_03v3 L=0.28u W=0.22u nf=1
M3 spike/reset spike_neg Vdd Vdd pfet_03v3 L=0.28u W=0.22u nf=1
M4 spike/reset spike_neg Vss Vss nfet_03v3 L=0.28u W=0.22u nf=1
M7 spike spike_neg Vdd Vdd pfet_03v3 L=0.28u W=0.22u nf=1
M8 spike spike_neg GND GND nfet_03v3 L=0.28u W=0.22u nf=1
M5 Iin spike/reset Vss Vss nfet_03v3 L=50u W=1.25u nf=1
XC2 Iin Vss cap_mim_2f0fF c_width=5e-6 c_length=5e-6 m=3
.ends
.GLOBAL GND
