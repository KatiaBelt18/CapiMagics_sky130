* NGSPICE file created from neurona.ext - technology: sky130A

.subckt m1 w_n366_n485# a_n106_n50# a_n33_n246# a_28_n50# VSUBS
X0 a_28_n50# a_n33_n246# a_n106_n50# w_n366_n485# sky130_fd_pr__pfet_01v8 ad=0.195 pd=1.78 as=0.195 ps=1.78 w=0.5 l=0.28
C0 a_n106_n50# a_28_n50# 0.25526f
C1 a_n33_n246# a_28_n50# 0.02013f
C2 a_n33_n246# a_n106_n50# 0.03602f
C3 w_n366_n485# a_28_n50# 0.23533f
C4 a_n106_n50# w_n366_n485# 0.11818f
C5 a_n33_n246# w_n366_n485# 0.27972f
C6 a_28_n50# VSUBS 0.02584f
C7 a_n106_n50# VSUBS 0.02549f
C8 a_n33_n246# VSUBS 0.04528f
C9 w_n366_n485# VSUBS 2.6935f
.ends

.subckt cap c1_n1620_n620# m3_n1620_n620# VSUBS
X0 c1_n1620_n620# m3_n1620_n620# sky130_fd_pr__cap_mim_m3_1 l=6.2 w=16.2
C0 m3_n1620_n620# c1_n1620_n620# 7.72008f
C1 c1_n1620_n620# VSUBS 1.37315f
C2 m3_n1620_n620# VSUBS 3.07879f
.ends

.subckt m6 w_n366_n485# a_n106_n50# a_n33_n246# a_28_n50# VSUBS
X0 a_28_n50# a_n33_n246# a_n106_n50# w_n366_n485# sky130_fd_pr__pfet_01v8 ad=0.195 pd=1.78 as=0.195 ps=1.78 w=0.5 l=0.28
C0 a_28_n50# a_n106_n50# 0.25526f
C1 w_n366_n485# a_n33_n246# 0.27972f
C2 a_28_n50# a_n33_n246# 0.02013f
C3 a_n106_n50# a_n33_n246# 0.03602f
C4 w_n366_n485# a_28_n50# 0.23533f
C5 w_n366_n485# a_n106_n50# 0.11818f
C6 a_28_n50# VSUBS 0.02584f
C7 a_n106_n50# VSUBS 0.02549f
C8 a_n33_n246# VSUBS 0.04528f
C9 w_n366_n485# VSUBS 2.6935f
.ends

.subckt m4 a_n320_n439# a_n106_n50# a_n33_n246# a_28_n50#
X0 a_28_n50# a_n33_n246# a_n106_n50# a_n320_n439# sky130_fd_pr__nfet_01v8 ad=0.195 pd=1.78 as=0.195 ps=1.78 w=0.5 l=0.28
C0 a_n33_n246# a_n106_n50# 0.03602f
C1 a_28_n50# a_n106_n50# 0.25526f
C2 a_n33_n246# a_28_n50# 0.02013f
C3 a_28_n50# a_n320_n439# 0.24224f
C4 a_n106_n50# a_n320_n439# 0.1375f
C5 a_n33_n246# a_n320_n439# 0.31664f
.ends

.subckt m2 a_n320_n439# a_n106_n50# a_n33_n246# a_28_n50#
X0 a_28_n50# a_n33_n246# a_n106_n50# a_n320_n439# sky130_fd_pr__nfet_01v8 ad=0.195 pd=1.78 as=0.195 ps=1.78 w=0.5 l=0.28
C0 a_n33_n246# a_n106_n50# 0.03602f
C1 a_28_n50# a_n106_n50# 0.25526f
C2 a_n33_n246# a_28_n50# 0.02013f
C3 a_28_n50# a_n320_n439# 0.24224f
C4 a_n106_n50# a_n320_n439# 0.1375f
C5 a_n33_n246# a_n320_n439# 0.31664f
.ends

.subckt m7 a_n320_n439# a_n106_n50# a_n33_n246# a_28_n50#
X0 a_28_n50# a_n33_n246# a_n106_n50# a_n320_n439# sky130_fd_pr__nfet_01v8 ad=0.195 pd=1.78 as=0.195 ps=1.78 w=0.5 l=0.28
C0 a_n33_n246# a_n106_n50# 0.03602f
C1 a_28_n50# a_n106_n50# 0.25526f
C2 a_n33_n246# a_28_n50# 0.02013f
C3 a_28_n50# a_n320_n439# 0.24224f
C4 a_n106_n50# a_n320_n439# 0.1375f
C5 a_n33_n246# a_n320_n439# 0.31664f
.ends

.subckt m5 a_n2078_n300# a_2000_n300# a_n2292_n689# a_n2000_n496#
X0 a_2000_n300# a_n2000_n496# a_n2078_n300# a_n2292_n689# sky130_fd_pr__nfet_01v8 ad=1.17 pd=6.78 as=1.17 ps=6.78 w=3 l=20
C0 a_n2000_n496# a_n2078_n300# 1.30716f
C1 a_2000_n300# a_n2078_n300# 2.38458f
C2 a_n2000_n496# a_2000_n300# 0.33408f
C3 a_2000_n300# a_n2292_n689# 2.01201f
C4 a_n2078_n300# a_n2292_n689# 0.62236f
C5 a_n2000_n496# a_n2292_n689# 7.42062f
.ends

.subckt m3 w_n366_n485# a_n106_n50# a_n33_n246# a_28_n50# VSUBS
X0 a_28_n50# a_n33_n246# a_n106_n50# w_n366_n485# sky130_fd_pr__pfet_01v8 ad=0.195 pd=1.78 as=0.195 ps=1.78 w=0.5 l=0.28
C0 a_n106_n50# a_28_n50# 0.25526f
C1 w_n366_n485# a_n33_n246# 0.27972f
C2 a_n106_n50# a_n33_n246# 0.03602f
C3 a_28_n50# a_n33_n246# 0.02013f
C4 w_n366_n485# a_n106_n50# 0.11818f
C5 w_n366_n485# a_28_n50# 0.23533f
C6 a_28_n50# VSUBS 0.02584f
C7 a_n106_n50# VSUBS 0.02549f
C8 a_n33_n246# VSUBS 0.04528f
C9 w_n366_n485# VSUBS 2.6935f
.ends

.subckt neurona vdd vss Iin spike_neg spike
Xm1_0 vdd vdd Iin spike_neg vss m1
Xcap_0 Iin vss vss cap
Xm6_0 vdd vdd spike_neg spike vss m6
Xm4_0 vss vss spike_neg m4_0/a_28_n50# m4
Xm2_0 vss vss Iin spike_neg m2
Xm7_0 vss vss spike_neg spike m7
Xm5_0 vss Iin vss m4_0/a_28_n50# m5
Xm3_0 vdd vdd spike_neg m4_0/a_28_n50# vss m3
R0 spike_neg.n3 spike_neg.n1 353.212
R1 spike_neg.n4 spike_neg.n0 340.985
R2 spike_neg.n6 spike_neg.n5 340.329
R3 spike_neg.n3 spike_neg.n2 340.329
R4 spike_neg spike_neg.n6 15.0687
R5 spike_neg.n6 spike_neg.n4 12.2884
R6 spike_neg.n4 spike_neg.n3 1.32247
R7 Iin.n3 Iin.n1 340.863
R8 Iin.n4 Iin.n0 340.832
R9 Iin.n3 Iin.n2 48.8568
R10 Iin.n4 Iin.n3 11.7846
R11 Iin Iin.n4 4.94936
R12 vss.n422 vss.n366 17344.6
R13 vss.n485 vss.n352 14226.7
R14 vss.n432 vss.n366 14226.7
R15 vss.n366 vss.n352 5784.46
R16 vss.n352 vss.n12 4943.69
R17 vss.n174 vss.n134 715.928
R18 vss.n565 vss.n11 715.928
R19 vss.n176 vss.n132 715.928
R20 vss.n568 vss.n9 715.928
R21 vss.n486 vss.n485 638.061
R22 vss.n421 vss.n379 634.245
R23 vss.n380 vss.n377 634.245
R24 vss.n430 vss.n373 634.245
R25 vss.n402 vss.n401 634.245
R26 vss.n474 vss.n365 634.245
R27 vss.n433 vss.n363 634.245
R28 vss.n483 vss.n359 634.245
R29 vss.n455 vss.n454 634.245
R30 vss.n511 vss.n350 634.245
R31 vss.n509 vss.n508 634.245
R32 vss.n531 vss.n340 634.245
R33 vss.n516 vss.n515 634.245
R34 vss.n427 vss.n373 589.749
R35 vss.n480 vss.n359 589.749
R36 vss.n340 vss.n336 589.749
R37 vss.n512 vss.n511 585
R38 vss.n511 vss.n510 585
R39 vss.n513 vss.n347 585
R40 vss.n351 vss.n347 585
R41 vss.n515 vss.n514 585
R42 vss.n515 vss.n341 585
R43 vss.n517 vss.n516 585
R44 vss.n519 vss.n518 585
R45 vss.n521 vss.n520 585
R46 vss.n523 vss.n522 585
R47 vss.n525 vss.n524 585
R48 vss.n526 vss.n345 585
R49 vss.n528 vss.n527 585
R50 vss.n339 vss.n338 585
R51 vss.n532 vss.n531 585
R52 vss.n531 vss.n530 585
R53 vss.n508 vss.n335 585
R54 vss.n506 vss.n505 585
R55 vss.n504 vss.n489 585
R56 vss.n503 vss.n502 585
R57 vss.n500 vss.n490 585
R58 vss.n498 vss.n497 585
R59 vss.n496 vss.n491 585
R60 vss.n495 vss.n494 585
R61 vss.n492 vss.n350 585
R62 vss.n486 vss.n350 585
R63 vss.n509 vss.n337 585
R64 vss.n510 vss.n509 585
R65 vss.n488 vss.n487 585
R66 vss.n488 vss.n351 585
R67 vss.n341 vss.n340 585
R68 vss.n458 vss.n365 585
R69 vss.n476 vss.n365 585
R70 vss.n457 vss.n364 585
R71 vss.n477 vss.n364 585
R72 vss.n456 vss.n455 585
R73 vss.n455 vss.n353 585
R74 vss.n454 vss.n453 585
R75 vss.n452 vss.n451 585
R76 vss.n450 vss.n449 585
R77 vss.n448 vss.n447 585
R78 vss.n446 vss.n445 585
R79 vss.n444 vss.n443 585
R80 vss.n442 vss.n441 585
R81 vss.n360 vss.n358 585
R82 vss.n483 vss.n482 585
R83 vss.n484 vss.n483 585
R84 vss.n433 vss.n361 585
R85 vss.n461 vss.n460 585
R86 vss.n463 vss.n462 585
R87 vss.n465 vss.n464 585
R88 vss.n467 vss.n466 585
R89 vss.n469 vss.n468 585
R90 vss.n471 vss.n470 585
R91 vss.n472 vss.n438 585
R92 vss.n474 vss.n473 585
R93 vss.n475 vss.n474 585
R94 vss.n363 vss.n362 585
R95 vss.n476 vss.n363 585
R96 vss.n479 vss.n478 585
R97 vss.n478 vss.n477 585
R98 vss.n359 vss.n353 585
R99 vss.n405 vss.n379 585
R100 vss.n423 vss.n379 585
R101 vss.n404 vss.n378 585
R102 vss.n424 vss.n378 585
R103 vss.n403 vss.n402 585
R104 vss.n402 vss.n367 585
R105 vss.n401 vss.n400 585
R106 vss.n399 vss.n398 585
R107 vss.n397 vss.n396 585
R108 vss.n395 vss.n394 585
R109 vss.n393 vss.n392 585
R110 vss.n391 vss.n390 585
R111 vss.n389 vss.n388 585
R112 vss.n374 vss.n372 585
R113 vss.n430 vss.n429 585
R114 vss.n431 vss.n430 585
R115 vss.n380 vss.n375 585
R116 vss.n408 vss.n407 585
R117 vss.n410 vss.n409 585
R118 vss.n412 vss.n411 585
R119 vss.n414 vss.n413 585
R120 vss.n416 vss.n415 585
R121 vss.n418 vss.n417 585
R122 vss.n419 vss.n385 585
R123 vss.n421 vss.n420 585
R124 vss.n422 vss.n421 585
R125 vss.n377 vss.n376 585
R126 vss.n423 vss.n377 585
R127 vss.n426 vss.n425 585
R128 vss.n425 vss.n424 585
R129 vss.n373 vss.n367 585
R130 vss.n174 vss.n173 585
R131 vss.n175 vss.n174 585
R132 vss.n127 vss.n126 585
R133 vss.n128 vss.n127 585
R134 vss.n185 vss.n184 585
R135 vss.n184 vss.n183 585
R136 vss.n124 vss.n123 585
R137 vss.n123 vss.n122 585
R138 vss.n190 vss.n189 585
R139 vss.n191 vss.n190 585
R140 vss.n115 vss.n114 585
R141 vss.n116 vss.n115 585
R142 vss.n201 vss.n200 585
R143 vss.n200 vss.n199 585
R144 vss.n112 vss.n111 585
R145 vss.n111 vss.n110 585
R146 vss.n206 vss.n205 585
R147 vss.n207 vss.n206 585
R148 vss.n103 vss.n102 585
R149 vss.n104 vss.n103 585
R150 vss.n217 vss.n216 585
R151 vss.n216 vss.n215 585
R152 vss.n100 vss.n99 585
R153 vss.n99 vss.n98 585
R154 vss.n222 vss.n221 585
R155 vss.n223 vss.n222 585
R156 vss.n91 vss.n90 585
R157 vss.n92 vss.n91 585
R158 vss.n233 vss.n232 585
R159 vss.n232 vss.n231 585
R160 vss.n88 vss.n87 585
R161 vss.n87 vss.n86 585
R162 vss.n238 vss.n237 585
R163 vss.n239 vss.n238 585
R164 vss.n79 vss.n78 585
R165 vss.n80 vss.n79 585
R166 vss.n249 vss.n248 585
R167 vss.n248 vss.n247 585
R168 vss.n76 vss.n75 585
R169 vss.n75 vss.n74 585
R170 vss.n254 vss.n253 585
R171 vss.n255 vss.n254 585
R172 vss.n67 vss.n66 585
R173 vss.n68 vss.n67 585
R174 vss.n265 vss.n264 585
R175 vss.n264 vss.n263 585
R176 vss.n64 vss.n63 585
R177 vss.n63 vss.n62 585
R178 vss.n270 vss.n269 585
R179 vss.n271 vss.n270 585
R180 vss.n55 vss.n54 585
R181 vss.n56 vss.n55 585
R182 vss.n281 vss.n280 585
R183 vss.n280 vss.n279 585
R184 vss.n51 vss.n50 585
R185 vss.n50 vss.n49 585
R186 vss.n287 vss.n286 585
R187 vss.n288 vss.n287 585
R188 vss.n52 vss.n42 585
R189 vss.n43 vss.n42 585
R190 vss.n297 vss.n41 585
R191 vss.n297 vss.n296 585
R192 vss.n299 vss.n298 585
R193 vss.n298 vss.n37 585
R194 vss.n39 vss.n38 585
R195 vss.n306 vss.n38 585
R196 vss.n304 vss.n303 585
R197 vss.n305 vss.n304 585
R198 vss.n30 vss.n29 585
R199 vss.n31 vss.n30 585
R200 vss.n317 vss.n316 585
R201 vss.n316 vss.n315 585
R202 vss.n26 vss.n25 585
R203 vss.n25 vss.n24 585
R204 vss.n324 vss.n323 585
R205 vss.n325 vss.n324 585
R206 vss.n27 vss.n23 585
R207 vss.n326 vss.n23 585
R208 vss.n329 vss.n22 585
R209 vss.n329 vss.n328 585
R210 vss.n331 vss.n330 585
R211 vss.n330 vss.n10 585
R212 vss.n332 vss.n11 585
R213 vss.n567 vss.n11 585
R214 vss.n569 vss.n568 585
R215 vss.n568 vss.n567 585
R216 vss.n570 vss.n8 585
R217 vss.n10 vss.n8 585
R218 vss.n327 vss.n6 585
R219 vss.n328 vss.n327 585
R220 vss.n574 vss.n5 585
R221 vss.n326 vss.n5 585
R222 vss.n575 vss.n4 585
R223 vss.n325 vss.n4 585
R224 vss.n576 vss.n3 585
R225 vss.n24 vss.n3 585
R226 vss.n314 vss.n2 585
R227 vss.n315 vss.n314 585
R228 vss.n313 vss.n312 585
R229 vss.n313 vss.n31 585
R230 vss.n33 vss.n32 585
R231 vss.n305 vss.n32 585
R232 vss.n308 vss.n307 585
R233 vss.n307 vss.n306 585
R234 vss.n36 vss.n35 585
R235 vss.n37 vss.n36 585
R236 vss.n295 vss.n294 585
R237 vss.n296 vss.n295 585
R238 vss.n45 vss.n44 585
R239 vss.n44 vss.n43 585
R240 vss.n290 vss.n289 585
R241 vss.n289 vss.n288 585
R242 vss.n48 vss.n47 585
R243 vss.n49 vss.n48 585
R244 vss.n278 vss.n277 585
R245 vss.n279 vss.n278 585
R246 vss.n58 vss.n57 585
R247 vss.n57 vss.n56 585
R248 vss.n273 vss.n272 585
R249 vss.n272 vss.n271 585
R250 vss.n61 vss.n60 585
R251 vss.n62 vss.n61 585
R252 vss.n262 vss.n261 585
R253 vss.n263 vss.n262 585
R254 vss.n70 vss.n69 585
R255 vss.n69 vss.n68 585
R256 vss.n257 vss.n256 585
R257 vss.n256 vss.n255 585
R258 vss.n73 vss.n72 585
R259 vss.n74 vss.n73 585
R260 vss.n246 vss.n245 585
R261 vss.n247 vss.n246 585
R262 vss.n82 vss.n81 585
R263 vss.n81 vss.n80 585
R264 vss.n241 vss.n240 585
R265 vss.n240 vss.n239 585
R266 vss.n85 vss.n84 585
R267 vss.n86 vss.n85 585
R268 vss.n230 vss.n229 585
R269 vss.n231 vss.n230 585
R270 vss.n94 vss.n93 585
R271 vss.n93 vss.n92 585
R272 vss.n225 vss.n224 585
R273 vss.n224 vss.n223 585
R274 vss.n97 vss.n96 585
R275 vss.n98 vss.n97 585
R276 vss.n214 vss.n213 585
R277 vss.n215 vss.n214 585
R278 vss.n106 vss.n105 585
R279 vss.n105 vss.n104 585
R280 vss.n209 vss.n208 585
R281 vss.n208 vss.n207 585
R282 vss.n109 vss.n108 585
R283 vss.n110 vss.n109 585
R284 vss.n198 vss.n197 585
R285 vss.n199 vss.n198 585
R286 vss.n118 vss.n117 585
R287 vss.n117 vss.n116 585
R288 vss.n193 vss.n192 585
R289 vss.n192 vss.n191 585
R290 vss.n121 vss.n120 585
R291 vss.n122 vss.n121 585
R292 vss.n182 vss.n181 585
R293 vss.n183 vss.n182 585
R294 vss.n130 vss.n129 585
R295 vss.n129 vss.n128 585
R296 vss.n177 vss.n176 585
R297 vss.n176 vss.n175 585
R298 vss.n536 vss.n9 585
R299 vss.n566 vss.n9 585
R300 vss.n538 vss.n537 585
R301 vss.n540 vss.n539 585
R302 vss.n542 vss.n541 585
R303 vss.n544 vss.n543 585
R304 vss.n546 vss.n545 585
R305 vss.n548 vss.n547 585
R306 vss.n550 vss.n549 585
R307 vss.n552 vss.n551 585
R308 vss.n554 vss.n553 585
R309 vss.n556 vss.n555 585
R310 vss.n558 vss.n557 585
R311 vss.n560 vss.n559 585
R312 vss.n562 vss.n561 585
R313 vss.n563 vss.n20 585
R314 vss.n565 vss.n564 585
R315 vss.n566 vss.n565 585
R316 vss.n171 vss.n134 585
R317 vss.n170 vss.n169 585
R318 vss.n167 vss.n135 585
R319 vss.n165 vss.n164 585
R320 vss.n163 vss.n136 585
R321 vss.n162 vss.n161 585
R322 vss.n159 vss.n137 585
R323 vss.n157 vss.n156 585
R324 vss.n155 vss.n138 585
R325 vss.n154 vss.n153 585
R326 vss.n151 vss.n139 585
R327 vss.n149 vss.n148 585
R328 vss.n147 vss.n140 585
R329 vss.n146 vss.n145 585
R330 vss.n143 vss.n141 585
R331 vss.n132 vss.n131 585
R332 vss.n475 vss.n432 573.652
R333 vss.n566 vss.n12 449.938
R334 vss.n432 vss.n431 444.832
R335 vss.n485 vss.n484 380.421
R336 vss.n530 vss.n341 360.293
R337 vss.n510 vss.n486 360.293
R338 vss.n484 vss.n353 360.293
R339 vss.n476 vss.n475 360.293
R340 vss.n431 vss.n367 360.293
R341 vss.n423 vss.n422 360.293
R342 vss.n530 vss.n342 256.663
R343 vss.n530 vss.n343 256.663
R344 vss.n530 vss.n344 256.663
R345 vss.n530 vss.n529 256.663
R346 vss.n507 vss.n486 256.663
R347 vss.n501 vss.n486 256.663
R348 vss.n499 vss.n486 256.663
R349 vss.n493 vss.n486 256.663
R350 vss.n484 vss.n354 256.663
R351 vss.n484 vss.n355 256.663
R352 vss.n484 vss.n356 256.663
R353 vss.n484 vss.n357 256.663
R354 vss.n475 vss.n434 256.663
R355 vss.n475 vss.n435 256.663
R356 vss.n475 vss.n436 256.663
R357 vss.n475 vss.n437 256.663
R358 vss.n431 vss.n368 256.663
R359 vss.n431 vss.n369 256.663
R360 vss.n431 vss.n370 256.663
R361 vss.n431 vss.n371 256.663
R362 vss.n422 vss.n381 256.663
R363 vss.n422 vss.n382 256.663
R364 vss.n422 vss.n383 256.663
R365 vss.n422 vss.n384 256.663
R366 vss.n566 vss.n13 256.663
R367 vss.n566 vss.n14 256.663
R368 vss.n566 vss.n15 256.663
R369 vss.n566 vss.n16 256.663
R370 vss.n566 vss.n17 256.663
R371 vss.n566 vss.n18 256.663
R372 vss.n566 vss.n19 256.663
R373 vss.n168 vss.n133 256.663
R374 vss.n166 vss.n133 256.663
R375 vss.n160 vss.n133 256.663
R376 vss.n158 vss.n133 256.663
R377 vss.n152 vss.n133 256.663
R378 vss.n150 vss.n133 256.663
R379 vss.n144 vss.n133 256.663
R380 vss.n142 vss.n133 256.663
R381 vss.n425 vss.n373 240.244
R382 vss.n425 vss.n377 240.244
R383 vss.n402 vss.n378 240.244
R384 vss.n379 vss.n378 240.244
R385 vss.n478 vss.n359 240.244
R386 vss.n478 vss.n363 240.244
R387 vss.n455 vss.n364 240.244
R388 vss.n365 vss.n364 240.244
R389 vss.n488 vss.n340 240.244
R390 vss.n509 vss.n488 240.244
R391 vss.n515 vss.n347 240.244
R392 vss.n511 vss.n347 240.244
R393 vss.n174 vss.n127 240.244
R394 vss.n184 vss.n127 240.244
R395 vss.n184 vss.n123 240.244
R396 vss.n190 vss.n123 240.244
R397 vss.n190 vss.n115 240.244
R398 vss.n200 vss.n115 240.244
R399 vss.n200 vss.n111 240.244
R400 vss.n206 vss.n111 240.244
R401 vss.n206 vss.n103 240.244
R402 vss.n216 vss.n103 240.244
R403 vss.n216 vss.n99 240.244
R404 vss.n222 vss.n99 240.244
R405 vss.n222 vss.n91 240.244
R406 vss.n232 vss.n91 240.244
R407 vss.n232 vss.n87 240.244
R408 vss.n238 vss.n87 240.244
R409 vss.n238 vss.n79 240.244
R410 vss.n248 vss.n79 240.244
R411 vss.n248 vss.n75 240.244
R412 vss.n254 vss.n75 240.244
R413 vss.n254 vss.n67 240.244
R414 vss.n264 vss.n67 240.244
R415 vss.n264 vss.n63 240.244
R416 vss.n270 vss.n63 240.244
R417 vss.n270 vss.n55 240.244
R418 vss.n280 vss.n55 240.244
R419 vss.n280 vss.n50 240.244
R420 vss.n287 vss.n50 240.244
R421 vss.n287 vss.n42 240.244
R422 vss.n297 vss.n42 240.244
R423 vss.n298 vss.n297 240.244
R424 vss.n298 vss.n38 240.244
R425 vss.n304 vss.n38 240.244
R426 vss.n304 vss.n30 240.244
R427 vss.n316 vss.n30 240.244
R428 vss.n316 vss.n25 240.244
R429 vss.n324 vss.n25 240.244
R430 vss.n324 vss.n23 240.244
R431 vss.n329 vss.n23 240.244
R432 vss.n330 vss.n329 240.244
R433 vss.n330 vss.n11 240.244
R434 vss.n176 vss.n129 240.244
R435 vss.n182 vss.n129 240.244
R436 vss.n182 vss.n121 240.244
R437 vss.n192 vss.n121 240.244
R438 vss.n192 vss.n117 240.244
R439 vss.n198 vss.n117 240.244
R440 vss.n198 vss.n109 240.244
R441 vss.n208 vss.n109 240.244
R442 vss.n208 vss.n105 240.244
R443 vss.n214 vss.n105 240.244
R444 vss.n214 vss.n97 240.244
R445 vss.n224 vss.n97 240.244
R446 vss.n224 vss.n93 240.244
R447 vss.n230 vss.n93 240.244
R448 vss.n230 vss.n85 240.244
R449 vss.n240 vss.n85 240.244
R450 vss.n240 vss.n81 240.244
R451 vss.n246 vss.n81 240.244
R452 vss.n246 vss.n73 240.244
R453 vss.n256 vss.n73 240.244
R454 vss.n256 vss.n69 240.244
R455 vss.n262 vss.n69 240.244
R456 vss.n262 vss.n61 240.244
R457 vss.n272 vss.n61 240.244
R458 vss.n272 vss.n57 240.244
R459 vss.n278 vss.n57 240.244
R460 vss.n278 vss.n48 240.244
R461 vss.n289 vss.n48 240.244
R462 vss.n289 vss.n44 240.244
R463 vss.n295 vss.n44 240.244
R464 vss.n295 vss.n36 240.244
R465 vss.n307 vss.n36 240.244
R466 vss.n307 vss.n32 240.244
R467 vss.n313 vss.n32 240.244
R468 vss.n314 vss.n313 240.244
R469 vss.n314 vss.n3 240.244
R470 vss.n4 vss.n3 240.244
R471 vss.n5 vss.n4 240.244
R472 vss.n327 vss.n5 240.244
R473 vss.n327 vss.n8 240.244
R474 vss.n568 vss.n8 240.244
R475 vss.n175 vss.n133 224.411
R476 vss.n567 vss.n566 224.411
R477 vss.n351 vss.n341 201.281
R478 vss.n510 vss.n351 201.281
R479 vss.n477 vss.n353 201.281
R480 vss.n477 vss.n476 201.281
R481 vss.n424 vss.n367 201.281
R482 vss.n424 vss.n423 201.281
R483 vss.n421 vss.n385 163.367
R484 vss.n417 vss.n416 163.367
R485 vss.n413 vss.n412 163.367
R486 vss.n409 vss.n408 163.367
R487 vss.n398 vss.n397 163.367
R488 vss.n394 vss.n393 163.367
R489 vss.n390 vss.n389 163.367
R490 vss.n430 vss.n372 163.367
R491 vss.n474 vss.n438 163.367
R492 vss.n470 vss.n469 163.367
R493 vss.n466 vss.n465 163.367
R494 vss.n462 vss.n461 163.367
R495 vss.n451 vss.n450 163.367
R496 vss.n447 vss.n446 163.367
R497 vss.n443 vss.n442 163.367
R498 vss.n483 vss.n358 163.367
R499 vss.n494 vss.n350 163.367
R500 vss.n498 vss.n491 163.367
R501 vss.n502 vss.n500 163.367
R502 vss.n506 vss.n489 163.367
R503 vss.n520 vss.n519 163.367
R504 vss.n524 vss.n523 163.367
R505 vss.n528 vss.n345 163.367
R506 vss.n531 vss.n339 163.367
R507 vss.n169 vss.n167 163.367
R508 vss.n165 vss.n136 163.367
R509 vss.n161 vss.n159 163.367
R510 vss.n157 vss.n138 163.367
R511 vss.n153 vss.n151 163.367
R512 vss.n149 vss.n140 163.367
R513 vss.n145 vss.n143 163.367
R514 vss.n565 vss.n20 163.367
R515 vss.n561 vss.n560 163.367
R516 vss.n557 vss.n556 163.367
R517 vss.n553 vss.n552 163.367
R518 vss.n549 vss.n548 163.367
R519 vss.n545 vss.n544 163.367
R520 vss.n541 vss.n540 163.367
R521 vss.n537 vss.n9 163.367
R522 vss.n175 vss.n128 111.647
R523 vss.n183 vss.n128 111.647
R524 vss.n183 vss.n122 111.647
R525 vss.n191 vss.n122 111.647
R526 vss.n191 vss.n116 111.647
R527 vss.n199 vss.n116 111.647
R528 vss.n199 vss.n110 111.647
R529 vss.n207 vss.n110 111.647
R530 vss.n207 vss.n104 111.647
R531 vss.n215 vss.n104 111.647
R532 vss.n215 vss.n98 111.647
R533 vss.n223 vss.n98 111.647
R534 vss.n223 vss.n92 111.647
R535 vss.n231 vss.n92 111.647
R536 vss.n231 vss.n86 111.647
R537 vss.n239 vss.n86 111.647
R538 vss.n239 vss.n80 111.647
R539 vss.n247 vss.n80 111.647
R540 vss.n247 vss.n74 111.647
R541 vss.n255 vss.n74 111.647
R542 vss.n255 vss.n68 111.647
R543 vss.n263 vss.n68 111.647
R544 vss.n263 vss.n62 111.647
R545 vss.n271 vss.n62 111.647
R546 vss.n271 vss.n56 111.647
R547 vss.n279 vss.n56 111.647
R548 vss.n279 vss.n49 111.647
R549 vss.n288 vss.n49 111.647
R550 vss.n288 vss.n43 111.647
R551 vss.n296 vss.n43 111.647
R552 vss.n296 vss.n37 111.647
R553 vss.n306 vss.n37 111.647
R554 vss.n306 vss.n305 111.647
R555 vss.n305 vss.n31 111.647
R556 vss.n315 vss.n31 111.647
R557 vss.n315 vss.n24 111.647
R558 vss.n325 vss.n24 111.647
R559 vss.n326 vss.n325 111.647
R560 vss.n328 vss.n326 111.647
R561 vss.n328 vss.n10 111.647
R562 vss.n567 vss.n10 111.647
R563 vss.n417 vss.n384 71.676
R564 vss.n413 vss.n383 71.676
R565 vss.n409 vss.n382 71.676
R566 vss.n381 vss.n380 71.676
R567 vss.n401 vss.n368 71.676
R568 vss.n397 vss.n369 71.676
R569 vss.n393 vss.n370 71.676
R570 vss.n389 vss.n371 71.676
R571 vss.n470 vss.n437 71.676
R572 vss.n466 vss.n436 71.676
R573 vss.n462 vss.n435 71.676
R574 vss.n434 vss.n433 71.676
R575 vss.n454 vss.n354 71.676
R576 vss.n450 vss.n355 71.676
R577 vss.n446 vss.n356 71.676
R578 vss.n442 vss.n357 71.676
R579 vss.n493 vss.n491 71.676
R580 vss.n500 vss.n499 71.676
R581 vss.n501 vss.n489 71.676
R582 vss.n508 vss.n507 71.676
R583 vss.n516 vss.n342 71.676
R584 vss.n520 vss.n343 71.676
R585 vss.n524 vss.n344 71.676
R586 vss.n529 vss.n528 71.676
R587 vss.n519 vss.n342 71.676
R588 vss.n523 vss.n343 71.676
R589 vss.n345 vss.n344 71.676
R590 vss.n529 vss.n339 71.676
R591 vss.n507 vss.n506 71.676
R592 vss.n502 vss.n501 71.676
R593 vss.n499 vss.n498 71.676
R594 vss.n494 vss.n493 71.676
R595 vss.n451 vss.n354 71.676
R596 vss.n447 vss.n355 71.676
R597 vss.n443 vss.n356 71.676
R598 vss.n358 vss.n357 71.676
R599 vss.n461 vss.n434 71.676
R600 vss.n465 vss.n435 71.676
R601 vss.n469 vss.n436 71.676
R602 vss.n438 vss.n437 71.676
R603 vss.n398 vss.n368 71.676
R604 vss.n394 vss.n369 71.676
R605 vss.n390 vss.n370 71.676
R606 vss.n372 vss.n371 71.676
R607 vss.n408 vss.n381 71.676
R608 vss.n412 vss.n382 71.676
R609 vss.n416 vss.n383 71.676
R610 vss.n385 vss.n384 71.676
R611 vss.n168 vss.n134 71.676
R612 vss.n167 vss.n166 71.676
R613 vss.n160 vss.n136 71.676
R614 vss.n159 vss.n158 71.676
R615 vss.n152 vss.n138 71.676
R616 vss.n151 vss.n150 71.676
R617 vss.n144 vss.n140 71.676
R618 vss.n143 vss.n142 71.676
R619 vss.n561 vss.n19 71.676
R620 vss.n557 vss.n18 71.676
R621 vss.n553 vss.n17 71.676
R622 vss.n549 vss.n16 71.676
R623 vss.n545 vss.n15 71.676
R624 vss.n541 vss.n14 71.676
R625 vss.n537 vss.n13 71.676
R626 vss.n540 vss.n13 71.676
R627 vss.n544 vss.n14 71.676
R628 vss.n548 vss.n15 71.676
R629 vss.n552 vss.n16 71.676
R630 vss.n556 vss.n17 71.676
R631 vss.n560 vss.n18 71.676
R632 vss.n20 vss.n19 71.676
R633 vss.n169 vss.n168 71.676
R634 vss.n166 vss.n165 71.676
R635 vss.n161 vss.n160 71.676
R636 vss.n158 vss.n157 71.676
R637 vss.n153 vss.n152 71.676
R638 vss.n150 vss.n149 71.676
R639 vss.n145 vss.n144 71.676
R640 vss.n142 vss.n132 71.676
R641 vss.n564 vss.n333 31.1484
R642 vss.n172 vss.n171 31.1484
R643 vss.n178 vss.n131 30.9455
R644 vss.n536 vss.n535 30.9045
R645 vss.n492 vss.n349 29.2417
R646 vss.n420 vss.n406 29.2417
R647 vss.n400 vss.n387 29.2417
R648 vss.n473 vss.n459 29.2417
R649 vss.n453 vss.n440 29.2417
R650 vss.n517 vss.n346 29.2417
R651 vss.n533 vss.n335 29.0313
R652 vss.n428 vss.n375 29.0313
R653 vss.n429 vss.n428 29.0313
R654 vss.n481 vss.n361 29.0313
R655 vss.n482 vss.n481 29.0313
R656 vss.n533 vss.n532 29.0313
R657 vss.n177 vss.n130 19.3944
R658 vss.n181 vss.n130 19.3944
R659 vss.n181 vss.n120 19.3944
R660 vss.n193 vss.n120 19.3944
R661 vss.n193 vss.n118 19.3944
R662 vss.n197 vss.n118 19.3944
R663 vss.n197 vss.n108 19.3944
R664 vss.n209 vss.n108 19.3944
R665 vss.n209 vss.n106 19.3944
R666 vss.n213 vss.n106 19.3944
R667 vss.n213 vss.n96 19.3944
R668 vss.n225 vss.n96 19.3944
R669 vss.n225 vss.n94 19.3944
R670 vss.n229 vss.n94 19.3944
R671 vss.n229 vss.n84 19.3944
R672 vss.n241 vss.n84 19.3944
R673 vss.n241 vss.n82 19.3944
R674 vss.n245 vss.n82 19.3944
R675 vss.n245 vss.n72 19.3944
R676 vss.n257 vss.n72 19.3944
R677 vss.n257 vss.n70 19.3944
R678 vss.n261 vss.n70 19.3944
R679 vss.n261 vss.n60 19.3944
R680 vss.n273 vss.n60 19.3944
R681 vss.n273 vss.n58 19.3944
R682 vss.n277 vss.n58 19.3944
R683 vss.n277 vss.n47 19.3944
R684 vss.n290 vss.n47 19.3944
R685 vss.n290 vss.n45 19.3944
R686 vss.n294 vss.n45 19.3944
R687 vss.n294 vss.n35 19.3944
R688 vss.n308 vss.n35 19.3944
R689 vss.n308 vss.n33 19.3944
R690 vss.n312 vss.n33 19.3944
R691 vss.n312 vss.n2 19.3944
R692 vss.n576 vss.n2 19.3944
R693 vss.n576 vss.n575 19.3944
R694 vss.n575 vss.n574 19.3944
R695 vss.n574 vss.n6 19.3944
R696 vss.n570 vss.n6 19.3944
R697 vss.n570 vss.n569 19.3944
R698 vss.n487 vss.n337 19.3944
R699 vss.n404 vss.n403 19.3944
R700 vss.n405 vss.n404 19.3944
R701 vss.n426 vss.n376 19.3944
R702 vss.n457 vss.n456 19.3944
R703 vss.n458 vss.n457 19.3944
R704 vss.n479 vss.n362 19.3944
R705 vss.n514 vss.n513 19.3944
R706 vss.n513 vss.n512 19.3944
R707 vss.n173 vss.n126 19.3944
R708 vss.n185 vss.n126 19.3944
R709 vss.n185 vss.n124 19.3944
R710 vss.n189 vss.n124 19.3944
R711 vss.n189 vss.n114 19.3944
R712 vss.n201 vss.n114 19.3944
R713 vss.n201 vss.n112 19.3944
R714 vss.n205 vss.n112 19.3944
R715 vss.n205 vss.n102 19.3944
R716 vss.n217 vss.n102 19.3944
R717 vss.n217 vss.n100 19.3944
R718 vss.n221 vss.n100 19.3944
R719 vss.n221 vss.n90 19.3944
R720 vss.n233 vss.n90 19.3944
R721 vss.n233 vss.n88 19.3944
R722 vss.n237 vss.n88 19.3944
R723 vss.n237 vss.n78 19.3944
R724 vss.n249 vss.n78 19.3944
R725 vss.n249 vss.n76 19.3944
R726 vss.n253 vss.n76 19.3944
R727 vss.n253 vss.n66 19.3944
R728 vss.n265 vss.n66 19.3944
R729 vss.n265 vss.n64 19.3944
R730 vss.n269 vss.n64 19.3944
R731 vss.n269 vss.n54 19.3944
R732 vss.n281 vss.n54 19.3944
R733 vss.n281 vss.n51 19.3944
R734 vss.n286 vss.n51 19.3944
R735 vss.n286 vss.n52 19.3944
R736 vss.n52 vss.n41 19.3944
R737 vss.n299 vss.n41 19.3944
R738 vss.n299 vss.n39 19.3944
R739 vss.n303 vss.n39 19.3944
R740 vss.n303 vss.n29 19.3944
R741 vss.n317 vss.n29 19.3944
R742 vss.n317 vss.n26 19.3944
R743 vss.n323 vss.n26 19.3944
R744 vss.n323 vss.n27 19.3944
R745 vss.n27 vss.n22 19.3944
R746 vss.n331 vss.n22 19.3944
R747 vss.n332 vss.n331 19.3944
R748 vss.n530 vss.n12 14.0902
R749 vss.n563 vss.n562 10.6151
R750 vss.n495 vss.n492 10.6151
R751 vss.n496 vss.n495 10.6151
R752 vss.n497 vss.n496 10.6151
R753 vss.n497 vss.n490 10.6151
R754 vss.n503 vss.n490 10.6151
R755 vss.n504 vss.n503 10.6151
R756 vss.n505 vss.n504 10.6151
R757 vss.n505 vss.n335 10.6151
R758 vss.n420 vss.n419 10.6151
R759 vss.n419 vss.n418 10.6151
R760 vss.n418 vss.n415 10.6151
R761 vss.n415 vss.n414 10.6151
R762 vss.n414 vss.n411 10.6151
R763 vss.n411 vss.n410 10.6151
R764 vss.n410 vss.n407 10.6151
R765 vss.n407 vss.n375 10.6151
R766 vss.n400 vss.n399 10.6151
R767 vss.n399 vss.n396 10.6151
R768 vss.n396 vss.n395 10.6151
R769 vss.n395 vss.n392 10.6151
R770 vss.n392 vss.n391 10.6151
R771 vss.n391 vss.n388 10.6151
R772 vss.n388 vss.n374 10.6151
R773 vss.n429 vss.n374 10.6151
R774 vss.n473 vss.n472 10.6151
R775 vss.n472 vss.n471 10.6151
R776 vss.n471 vss.n468 10.6151
R777 vss.n468 vss.n467 10.6151
R778 vss.n467 vss.n464 10.6151
R779 vss.n464 vss.n463 10.6151
R780 vss.n463 vss.n460 10.6151
R781 vss.n460 vss.n361 10.6151
R782 vss.n453 vss.n452 10.6151
R783 vss.n452 vss.n449 10.6151
R784 vss.n449 vss.n448 10.6151
R785 vss.n448 vss.n445 10.6151
R786 vss.n445 vss.n444 10.6151
R787 vss.n444 vss.n441 10.6151
R788 vss.n441 vss.n360 10.6151
R789 vss.n482 vss.n360 10.6151
R790 vss.n518 vss.n517 10.6151
R791 vss.n521 vss.n518 10.6151
R792 vss.n522 vss.n521 10.6151
R793 vss.n525 vss.n522 10.6151
R794 vss.n526 vss.n525 10.6151
R795 vss.n527 vss.n526 10.6151
R796 vss.n527 vss.n338 10.6151
R797 vss.n532 vss.n338 10.6151
R798 vss.n564 vss.n563 10.6151
R799 vss.n562 vss.n559 10.6151
R800 vss.n559 vss.n558 10.6151
R801 vss.n558 vss.n555 10.6151
R802 vss.n555 vss.n554 10.6151
R803 vss.n554 vss.n551 10.6151
R804 vss.n551 vss.n550 10.6151
R805 vss.n550 vss.n547 10.6151
R806 vss.n547 vss.n546 10.6151
R807 vss.n546 vss.n543 10.6151
R808 vss.n543 vss.n542 10.6151
R809 vss.n542 vss.n539 10.6151
R810 vss.n539 vss.n538 10.6151
R811 vss.n538 vss.n536 10.6151
R812 vss.n171 vss.n170 10.6151
R813 vss.n170 vss.n135 10.6151
R814 vss.n164 vss.n135 10.6151
R815 vss.n164 vss.n163 10.6151
R816 vss.n163 vss.n162 10.6151
R817 vss.n162 vss.n137 10.6151
R818 vss.n156 vss.n137 10.6151
R819 vss.n156 vss.n155 10.6151
R820 vss.n155 vss.n154 10.6151
R821 vss.n154 vss.n139 10.6151
R822 vss.n148 vss.n139 10.6151
R823 vss.n148 vss.n147 10.6151
R824 vss.n147 vss.n146 10.6151
R825 vss.n146 vss.n141 10.6151
R826 vss.n141 vss.n131 10.6151
R827 vss.n404 vss.n386 9.3005
R828 vss.n406 vss.n405 9.3005
R829 vss.n403 vss.n387 9.3005
R830 vss.n428 vss.n376 9.3005
R831 vss.n457 vss.n439 9.3005
R832 vss.n459 vss.n458 9.3005
R833 vss.n456 vss.n440 9.3005
R834 vss.n481 vss.n362 9.3005
R835 vss.n533 vss.n337 9.3005
R836 vss.n513 vss.n348 9.3005
R837 vss.n512 vss.n349 9.3005
R838 vss.n514 vss.n346 9.3005
R839 vss.n173 vss.n172 9.3005
R840 vss.n126 vss.n125 9.3005
R841 vss.n186 vss.n185 9.3005
R842 vss.n187 vss.n124 9.3005
R843 vss.n189 vss.n188 9.3005
R844 vss.n114 vss.n113 9.3005
R845 vss.n202 vss.n201 9.3005
R846 vss.n203 vss.n112 9.3005
R847 vss.n205 vss.n204 9.3005
R848 vss.n102 vss.n101 9.3005
R849 vss.n218 vss.n217 9.3005
R850 vss.n219 vss.n100 9.3005
R851 vss.n221 vss.n220 9.3005
R852 vss.n90 vss.n89 9.3005
R853 vss.n234 vss.n233 9.3005
R854 vss.n235 vss.n88 9.3005
R855 vss.n237 vss.n236 9.3005
R856 vss.n78 vss.n77 9.3005
R857 vss.n250 vss.n249 9.3005
R858 vss.n251 vss.n76 9.3005
R859 vss.n253 vss.n252 9.3005
R860 vss.n66 vss.n65 9.3005
R861 vss.n266 vss.n265 9.3005
R862 vss.n267 vss.n64 9.3005
R863 vss.n269 vss.n268 9.3005
R864 vss.n54 vss.n53 9.3005
R865 vss.n282 vss.n281 9.3005
R866 vss.n283 vss.n51 9.3005
R867 vss.n286 vss.n285 9.3005
R868 vss.n284 vss.n52 9.3005
R869 vss.n41 vss.n40 9.3005
R870 vss.n300 vss.n299 9.3005
R871 vss.n301 vss.n39 9.3005
R872 vss.n303 vss.n302 9.3005
R873 vss.n29 vss.n28 9.3005
R874 vss.n318 vss.n317 9.3005
R875 vss.n319 vss.n26 9.3005
R876 vss.n323 vss.n322 9.3005
R877 vss.n321 vss.n27 9.3005
R878 vss.n320 vss.n22 9.3005
R879 vss.n331 vss.n21 9.3005
R880 vss.n333 vss.n332 9.3005
R881 vss.n179 vss.n130 9.3005
R882 vss.n181 vss.n180 9.3005
R883 vss.n120 vss.n119 9.3005
R884 vss.n194 vss.n193 9.3005
R885 vss.n195 vss.n118 9.3005
R886 vss.n197 vss.n196 9.3005
R887 vss.n108 vss.n107 9.3005
R888 vss.n210 vss.n209 9.3005
R889 vss.n211 vss.n106 9.3005
R890 vss.n213 vss.n212 9.3005
R891 vss.n96 vss.n95 9.3005
R892 vss.n226 vss.n225 9.3005
R893 vss.n227 vss.n94 9.3005
R894 vss.n229 vss.n228 9.3005
R895 vss.n84 vss.n83 9.3005
R896 vss.n242 vss.n241 9.3005
R897 vss.n243 vss.n82 9.3005
R898 vss.n245 vss.n244 9.3005
R899 vss.n72 vss.n71 9.3005
R900 vss.n258 vss.n257 9.3005
R901 vss.n259 vss.n70 9.3005
R902 vss.n261 vss.n260 9.3005
R903 vss.n60 vss.n59 9.3005
R904 vss.n274 vss.n273 9.3005
R905 vss.n275 vss.n58 9.3005
R906 vss.n277 vss.n276 9.3005
R907 vss.n47 vss.n46 9.3005
R908 vss.n291 vss.n290 9.3005
R909 vss.n292 vss.n45 9.3005
R910 vss.n294 vss.n293 9.3005
R911 vss.n35 vss.n34 9.3005
R912 vss.n309 vss.n308 9.3005
R913 vss.n310 vss.n33 9.3005
R914 vss.n312 vss.n311 9.3005
R915 vss.n2 vss.n0 9.3005
R916 vss.n577 vss.n576 9.3005
R917 vss.n575 vss.n1 9.3005
R918 vss.n574 vss.n573 9.3005
R919 vss.n572 vss.n6 9.3005
R920 vss.n571 vss.n570 9.3005
R921 vss.n569 vss.n7 9.3005
R922 vss.n178 vss.n177 9.3005
R923 vss vss.n578 7.9105
R924 vss.n487 vss.n336 4.74817
R925 vss.n427 vss.n426 4.74817
R926 vss.n480 vss.n479 4.74817
R927 vss.n428 vss.n427 2.27742
R928 vss.n481 vss.n480 2.27742
R929 vss.n533 vss.n336 2.27742
R930 vss.n428 vss.n334 1.02663
R931 vss.n534 vss.n334 0.855151
R932 vss.n535 vss.n534 0.715616
R933 vss.n481 vss.n334 0.171981
R934 vss.n534 vss.n533 0.171981
R935 vss.n387 vss.n386 0.152939
R936 vss.n406 vss.n386 0.152939
R937 vss.n440 vss.n439 0.152939
R938 vss.n459 vss.n439 0.152939
R939 vss.n348 vss.n346 0.152939
R940 vss.n349 vss.n348 0.152939
R941 vss.n172 vss.n125 0.152939
R942 vss.n186 vss.n125 0.152939
R943 vss.n187 vss.n186 0.152939
R944 vss.n188 vss.n187 0.152939
R945 vss.n188 vss.n113 0.152939
R946 vss.n202 vss.n113 0.152939
R947 vss.n203 vss.n202 0.152939
R948 vss.n204 vss.n203 0.152939
R949 vss.n204 vss.n101 0.152939
R950 vss.n218 vss.n101 0.152939
R951 vss.n219 vss.n218 0.152939
R952 vss.n220 vss.n219 0.152939
R953 vss.n220 vss.n89 0.152939
R954 vss.n234 vss.n89 0.152939
R955 vss.n235 vss.n234 0.152939
R956 vss.n236 vss.n235 0.152939
R957 vss.n236 vss.n77 0.152939
R958 vss.n250 vss.n77 0.152939
R959 vss.n251 vss.n250 0.152939
R960 vss.n252 vss.n251 0.152939
R961 vss.n252 vss.n65 0.152939
R962 vss.n266 vss.n65 0.152939
R963 vss.n267 vss.n266 0.152939
R964 vss.n268 vss.n267 0.152939
R965 vss.n268 vss.n53 0.152939
R966 vss.n282 vss.n53 0.152939
R967 vss.n283 vss.n282 0.152939
R968 vss.n285 vss.n283 0.152939
R969 vss.n285 vss.n284 0.152939
R970 vss.n284 vss.n40 0.152939
R971 vss.n300 vss.n40 0.152939
R972 vss.n301 vss.n300 0.152939
R973 vss.n302 vss.n301 0.152939
R974 vss.n302 vss.n28 0.152939
R975 vss.n318 vss.n28 0.152939
R976 vss.n319 vss.n318 0.152939
R977 vss.n322 vss.n319 0.152939
R978 vss.n322 vss.n321 0.152939
R979 vss.n321 vss.n320 0.152939
R980 vss.n320 vss.n21 0.152939
R981 vss.n333 vss.n21 0.152939
R982 vss.n535 vss.n7 0.0415678
R983 vss.n179 vss.n178 0.0261674
R984 vss.n180 vss.n179 0.0261674
R985 vss.n180 vss.n119 0.0261674
R986 vss.n194 vss.n119 0.0261674
R987 vss.n195 vss.n194 0.0261674
R988 vss.n196 vss.n195 0.0261674
R989 vss.n196 vss.n107 0.0261674
R990 vss.n210 vss.n107 0.0261674
R991 vss.n211 vss.n210 0.0261674
R992 vss.n212 vss.n211 0.0261674
R993 vss.n212 vss.n95 0.0261674
R994 vss.n226 vss.n95 0.0261674
R995 vss.n227 vss.n226 0.0261674
R996 vss.n228 vss.n227 0.0261674
R997 vss.n228 vss.n83 0.0261674
R998 vss.n242 vss.n83 0.0261674
R999 vss.n243 vss.n242 0.0261674
R1000 vss.n244 vss.n243 0.0261674
R1001 vss.n244 vss.n71 0.0261674
R1002 vss.n258 vss.n71 0.0261674
R1003 vss.n259 vss.n258 0.0261674
R1004 vss.n260 vss.n259 0.0261674
R1005 vss.n260 vss.n59 0.0261674
R1006 vss.n274 vss.n59 0.0261674
R1007 vss.n275 vss.n274 0.0261674
R1008 vss.n276 vss.n275 0.0261674
R1009 vss.n276 vss.n46 0.0261674
R1010 vss.n291 vss.n46 0.0261674
R1011 vss.n292 vss.n291 0.0261674
R1012 vss.n293 vss.n292 0.0261674
R1013 vss.n293 vss.n34 0.0261674
R1014 vss.n309 vss.n34 0.0261674
R1015 vss.n310 vss.n309 0.0261674
R1016 vss.n311 vss.n310 0.0261674
R1017 vss.n311 vss.n0 0.0261674
R1018 vss.n577 vss.n1 0.0261674
R1019 vss.n573 vss.n1 0.0261674
R1020 vss.n573 vss.n572 0.0261674
R1021 vss.n572 vss.n571 0.0261674
R1022 vss.n571 vss.n7 0.0261674
R1023 vss.n578 vss.n0 0.025654
R1024 vss.n578 vss.n577 0.00101335
R1025 vdd.n57 vdd.n5 360
R1026 vdd.n39 vdd.n22 360
R1027 vdd.n41 vdd.n19 360
R1028 vdd.n54 vdd.n8 360
R1029 vdd.n115 vdd.n65 360
R1030 vdd.n97 vdd.n80 360
R1031 vdd.n99 vdd.n77 360
R1032 vdd.n112 vdd.n63 360
R1033 vdd.n176 vdd.n126 360
R1034 vdd.n158 vdd.n141 360
R1035 vdd.n160 vdd.n138 360
R1036 vdd.n173 vdd.n124 360
R1037 vdd.n8 vdd.n2 189.749
R1038 vdd.n118 vdd.n63 189.749
R1039 vdd.n179 vdd.n124 189.749
R1040 vdd.n39 vdd.n38 185
R1041 vdd.n40 vdd.n39 185
R1042 vdd.n30 vdd.n21 185
R1043 vdd.n21 vdd.n16 185
R1044 vdd.n29 vdd.n15 185
R1045 vdd.n46 vdd.n15 185
R1046 vdd.n28 vdd.n14 185
R1047 vdd.n47 vdd.n14 185
R1048 vdd.n27 vdd.n13 185
R1049 vdd.n48 vdd.n13 185
R1050 vdd.n26 vdd.n25 185
R1051 vdd.n25 vdd.n12 185
R1052 vdd.n24 vdd.n23 185
R1053 vdd.n24 vdd.n7 185
R1054 vdd.n5 vdd.n1 185
R1055 vdd.n55 vdd.n5 185
R1056 vdd.n36 vdd.n22 185
R1057 vdd.n35 vdd.n34 185
R1058 vdd.n32 vdd.n19 185
R1059 vdd.n20 vdd.n19 185
R1060 vdd.n54 vdd.n0 185
R1061 vdd.n55 vdd.n54 185
R1062 vdd.n53 vdd.n52 185
R1063 vdd.n53 vdd.n7 185
R1064 vdd.n51 vdd.n9 185
R1065 vdd.n12 vdd.n9 185
R1066 vdd.n50 vdd.n49 185
R1067 vdd.n49 vdd.n48 185
R1068 vdd.n11 vdd.n10 185
R1069 vdd.n47 vdd.n11 185
R1070 vdd.n45 vdd.n44 185
R1071 vdd.n46 vdd.n45 185
R1072 vdd.n43 vdd.n17 185
R1073 vdd.n17 vdd.n16 185
R1074 vdd.n42 vdd.n41 185
R1075 vdd.n41 vdd.n40 185
R1076 vdd.n4 vdd.n3 185
R1077 vdd.n58 vdd.n57 185
R1078 vdd.n57 vdd.n56 185
R1079 vdd.n97 vdd.n96 185
R1080 vdd.n98 vdd.n97 185
R1081 vdd.n88 vdd.n79 185
R1082 vdd.n79 vdd.n74 185
R1083 vdd.n87 vdd.n73 185
R1084 vdd.n104 vdd.n73 185
R1085 vdd.n86 vdd.n72 185
R1086 vdd.n105 vdd.n72 185
R1087 vdd.n85 vdd.n71 185
R1088 vdd.n106 vdd.n71 185
R1089 vdd.n84 vdd.n83 185
R1090 vdd.n83 vdd.n70 185
R1091 vdd.n82 vdd.n81 185
R1092 vdd.n82 vdd.n66 185
R1093 vdd.n65 vdd.n61 185
R1094 vdd.n113 vdd.n65 185
R1095 vdd.n94 vdd.n80 185
R1096 vdd.n93 vdd.n92 185
R1097 vdd.n90 vdd.n77 185
R1098 vdd.n78 vdd.n77 185
R1099 vdd.n112 vdd.n60 185
R1100 vdd.n113 vdd.n112 185
R1101 vdd.n111 vdd.n110 185
R1102 vdd.n111 vdd.n66 185
R1103 vdd.n109 vdd.n67 185
R1104 vdd.n70 vdd.n67 185
R1105 vdd.n108 vdd.n107 185
R1106 vdd.n107 vdd.n106 185
R1107 vdd.n69 vdd.n68 185
R1108 vdd.n105 vdd.n69 185
R1109 vdd.n103 vdd.n102 185
R1110 vdd.n104 vdd.n103 185
R1111 vdd.n101 vdd.n75 185
R1112 vdd.n75 vdd.n74 185
R1113 vdd.n100 vdd.n99 185
R1114 vdd.n99 vdd.n98 185
R1115 vdd.n115 vdd.n62 185
R1116 vdd.n115 vdd.n114 185
R1117 vdd.n117 vdd.n116 185
R1118 vdd.n158 vdd.n157 185
R1119 vdd.n159 vdd.n158 185
R1120 vdd.n149 vdd.n140 185
R1121 vdd.n140 vdd.n135 185
R1122 vdd.n148 vdd.n134 185
R1123 vdd.n165 vdd.n134 185
R1124 vdd.n147 vdd.n133 185
R1125 vdd.n166 vdd.n133 185
R1126 vdd.n146 vdd.n132 185
R1127 vdd.n167 vdd.n132 185
R1128 vdd.n145 vdd.n144 185
R1129 vdd.n144 vdd.n131 185
R1130 vdd.n143 vdd.n142 185
R1131 vdd.n143 vdd.n127 185
R1132 vdd.n126 vdd.n122 185
R1133 vdd.n174 vdd.n126 185
R1134 vdd.n155 vdd.n141 185
R1135 vdd.n154 vdd.n153 185
R1136 vdd.n151 vdd.n138 185
R1137 vdd.n139 vdd.n138 185
R1138 vdd.n173 vdd.n121 185
R1139 vdd.n174 vdd.n173 185
R1140 vdd.n172 vdd.n171 185
R1141 vdd.n172 vdd.n127 185
R1142 vdd.n170 vdd.n128 185
R1143 vdd.n131 vdd.n128 185
R1144 vdd.n169 vdd.n168 185
R1145 vdd.n168 vdd.n167 185
R1146 vdd.n130 vdd.n129 185
R1147 vdd.n166 vdd.n130 185
R1148 vdd.n164 vdd.n163 185
R1149 vdd.n165 vdd.n164 185
R1150 vdd.n162 vdd.n136 185
R1151 vdd.n136 vdd.n135 185
R1152 vdd.n161 vdd.n160 185
R1153 vdd.n160 vdd.n159 185
R1154 vdd.n176 vdd.n123 185
R1155 vdd.n176 vdd.n175 185
R1156 vdd.n178 vdd.n177 185
R1157 vdd.n56 vdd.n55 173.907
R1158 vdd.n40 vdd.n20 173.907
R1159 vdd.n114 vdd.n113 173.907
R1160 vdd.n98 vdd.n78 173.907
R1161 vdd.n175 vdd.n174 173.907
R1162 vdd.n159 vdd.n139 173.907
R1163 vdd.n34 vdd.n19 146.341
R1164 vdd.n57 vdd.n4 146.341
R1165 vdd.n92 vdd.n77 146.341
R1166 vdd.n116 vdd.n115 146.341
R1167 vdd.n153 vdd.n138 146.341
R1168 vdd.n177 vdd.n176 146.341
R1169 vdd.n24 vdd.n5 99.5127
R1170 vdd.n25 vdd.n24 99.5127
R1171 vdd.n25 vdd.n13 99.5127
R1172 vdd.n14 vdd.n13 99.5127
R1173 vdd.n15 vdd.n14 99.5127
R1174 vdd.n21 vdd.n15 99.5127
R1175 vdd.n39 vdd.n21 99.5127
R1176 vdd.n54 vdd.n53 99.5127
R1177 vdd.n53 vdd.n9 99.5127
R1178 vdd.n49 vdd.n9 99.5127
R1179 vdd.n49 vdd.n11 99.5127
R1180 vdd.n45 vdd.n11 99.5127
R1181 vdd.n45 vdd.n17 99.5127
R1182 vdd.n41 vdd.n17 99.5127
R1183 vdd.n82 vdd.n65 99.5127
R1184 vdd.n83 vdd.n82 99.5127
R1185 vdd.n83 vdd.n71 99.5127
R1186 vdd.n72 vdd.n71 99.5127
R1187 vdd.n73 vdd.n72 99.5127
R1188 vdd.n79 vdd.n73 99.5127
R1189 vdd.n97 vdd.n79 99.5127
R1190 vdd.n112 vdd.n111 99.5127
R1191 vdd.n111 vdd.n67 99.5127
R1192 vdd.n107 vdd.n67 99.5127
R1193 vdd.n107 vdd.n69 99.5127
R1194 vdd.n103 vdd.n69 99.5127
R1195 vdd.n103 vdd.n75 99.5127
R1196 vdd.n99 vdd.n75 99.5127
R1197 vdd.n143 vdd.n126 99.5127
R1198 vdd.n144 vdd.n143 99.5127
R1199 vdd.n144 vdd.n132 99.5127
R1200 vdd.n133 vdd.n132 99.5127
R1201 vdd.n134 vdd.n133 99.5127
R1202 vdd.n140 vdd.n134 99.5127
R1203 vdd.n158 vdd.n140 99.5127
R1204 vdd.n173 vdd.n172 99.5127
R1205 vdd.n172 vdd.n128 99.5127
R1206 vdd.n168 vdd.n128 99.5127
R1207 vdd.n168 vdd.n130 99.5127
R1208 vdd.n164 vdd.n130 99.5127
R1209 vdd.n164 vdd.n136 99.5127
R1210 vdd.n160 vdd.n136 99.5127
R1211 vdd.n55 vdd.n7 88.2519
R1212 vdd.n12 vdd.n7 88.2519
R1213 vdd.n48 vdd.n12 88.2519
R1214 vdd.n48 vdd.n47 88.2519
R1215 vdd.n47 vdd.n46 88.2519
R1216 vdd.n46 vdd.n16 88.2519
R1217 vdd.n40 vdd.n16 88.2519
R1218 vdd.n113 vdd.n66 88.2519
R1219 vdd.n70 vdd.n66 88.2519
R1220 vdd.n106 vdd.n70 88.2519
R1221 vdd.n106 vdd.n105 88.2519
R1222 vdd.n105 vdd.n104 88.2519
R1223 vdd.n104 vdd.n74 88.2519
R1224 vdd.n98 vdd.n74 88.2519
R1225 vdd.n174 vdd.n127 88.2519
R1226 vdd.n131 vdd.n127 88.2519
R1227 vdd.n167 vdd.n131 88.2519
R1228 vdd.n167 vdd.n166 88.2519
R1229 vdd.n166 vdd.n165 88.2519
R1230 vdd.n165 vdd.n135 88.2519
R1231 vdd.n159 vdd.n135 88.2519
R1232 vdd.n33 vdd.n20 66.2847
R1233 vdd.n56 vdd.n6 66.2847
R1234 vdd.n91 vdd.n78 66.2847
R1235 vdd.n114 vdd.n64 66.2847
R1236 vdd.n152 vdd.n139 66.2847
R1237 vdd.n175 vdd.n125 66.2847
R1238 vdd.n33 vdd.n22 52.4337
R1239 vdd.n34 vdd.n33 52.4337
R1240 vdd.n6 vdd.n4 52.4337
R1241 vdd.n8 vdd.n6 52.4337
R1242 vdd.n91 vdd.n80 52.4337
R1243 vdd.n92 vdd.n91 52.4337
R1244 vdd.n116 vdd.n64 52.4337
R1245 vdd.n64 vdd.n63 52.4337
R1246 vdd.n152 vdd.n141 52.4337
R1247 vdd.n153 vdd.n152 52.4337
R1248 vdd.n177 vdd.n125 52.4337
R1249 vdd.n125 vdd.n124 52.4337
R1250 vdd.n42 vdd.n18 30.4508
R1251 vdd.n38 vdd.n37 30.4508
R1252 vdd.n100 vdd.n76 30.4508
R1253 vdd.n96 vdd.n95 30.4508
R1254 vdd.n161 vdd.n137 30.4508
R1255 vdd.n157 vdd.n156 30.4508
R1256 vdd.n59 vdd.n0 30.2801
R1257 vdd.n59 vdd.n1 30.2801
R1258 vdd.n119 vdd.n60 30.2801
R1259 vdd.n119 vdd.n61 30.2801
R1260 vdd.n180 vdd.n121 30.2801
R1261 vdd.n180 vdd.n122 30.2801
R1262 vdd.n35 vdd.n32 19.3944
R1263 vdd.n36 vdd.n35 19.3944
R1264 vdd.n58 vdd.n3 19.3944
R1265 vdd.n93 vdd.n90 19.3944
R1266 vdd.n94 vdd.n93 19.3944
R1267 vdd.n117 vdd.n62 19.3944
R1268 vdd.n154 vdd.n151 19.3944
R1269 vdd.n155 vdd.n154 19.3944
R1270 vdd.n178 vdd.n123 19.3944
R1271 vdd.n52 vdd.n0 10.6151
R1272 vdd.n52 vdd.n51 10.6151
R1273 vdd.n51 vdd.n50 10.6151
R1274 vdd.n50 vdd.n10 10.6151
R1275 vdd.n44 vdd.n10 10.6151
R1276 vdd.n44 vdd.n43 10.6151
R1277 vdd.n43 vdd.n42 10.6151
R1278 vdd.n23 vdd.n1 10.6151
R1279 vdd.n26 vdd.n23 10.6151
R1280 vdd.n27 vdd.n26 10.6151
R1281 vdd.n28 vdd.n27 10.6151
R1282 vdd.n29 vdd.n28 10.6151
R1283 vdd.n30 vdd.n29 10.6151
R1284 vdd.n38 vdd.n30 10.6151
R1285 vdd.n110 vdd.n60 10.6151
R1286 vdd.n110 vdd.n109 10.6151
R1287 vdd.n109 vdd.n108 10.6151
R1288 vdd.n108 vdd.n68 10.6151
R1289 vdd.n102 vdd.n68 10.6151
R1290 vdd.n102 vdd.n101 10.6151
R1291 vdd.n101 vdd.n100 10.6151
R1292 vdd.n81 vdd.n61 10.6151
R1293 vdd.n84 vdd.n81 10.6151
R1294 vdd.n85 vdd.n84 10.6151
R1295 vdd.n86 vdd.n85 10.6151
R1296 vdd.n87 vdd.n86 10.6151
R1297 vdd.n88 vdd.n87 10.6151
R1298 vdd.n96 vdd.n88 10.6151
R1299 vdd.n171 vdd.n121 10.6151
R1300 vdd.n171 vdd.n170 10.6151
R1301 vdd.n170 vdd.n169 10.6151
R1302 vdd.n169 vdd.n129 10.6151
R1303 vdd.n163 vdd.n129 10.6151
R1304 vdd.n163 vdd.n162 10.6151
R1305 vdd.n162 vdd.n161 10.6151
R1306 vdd.n142 vdd.n122 10.6151
R1307 vdd.n145 vdd.n142 10.6151
R1308 vdd.n146 vdd.n145 10.6151
R1309 vdd.n147 vdd.n146 10.6151
R1310 vdd.n148 vdd.n147 10.6151
R1311 vdd.n149 vdd.n148 10.6151
R1312 vdd.n157 vdd.n149 10.6151
R1313 vdd vdd.n181 9.7419
R1314 vdd.n35 vdd.n31 9.3005
R1315 vdd.n37 vdd.n36 9.3005
R1316 vdd.n32 vdd.n18 9.3005
R1317 vdd.n59 vdd.n58 9.3005
R1318 vdd.n93 vdd.n89 9.3005
R1319 vdd.n95 vdd.n94 9.3005
R1320 vdd.n90 vdd.n76 9.3005
R1321 vdd.n119 vdd.n62 9.3005
R1322 vdd.n154 vdd.n150 9.3005
R1323 vdd.n156 vdd.n155 9.3005
R1324 vdd.n151 vdd.n137 9.3005
R1325 vdd.n180 vdd.n123 9.3005
R1326 vdd.n3 vdd.n2 4.74817
R1327 vdd.n118 vdd.n117 4.74817
R1328 vdd.n179 vdd.n178 4.74817
R1329 vdd.n59 vdd.n2 2.27742
R1330 vdd.n119 vdd.n118 2.27742
R1331 vdd.n180 vdd.n179 2.27742
R1332 vdd.n120 vdd.n59 1.10474
R1333 vdd.n181 vdd.n120 0.884221
R1334 vdd.n120 vdd.n119 0.221019
R1335 vdd.n181 vdd.n180 0.221019
R1336 vdd.n31 vdd.n18 0.152939
R1337 vdd.n37 vdd.n31 0.152939
R1338 vdd.n89 vdd.n76 0.152939
R1339 vdd.n95 vdd.n89 0.152939
R1340 vdd.n150 vdd.n137 0.152939
R1341 vdd.n156 vdd.n150 0.152939
C0 spike_neg vdd 1.24323f
C1 m4_0/a_28_n50# spike 0.05098f
C2 m4_0/a_28_n50# Iin 0.30496f
C3 Iin spike 0.36296f
C4 m4_0/a_28_n50# vdd 0.34993f
C5 spike vdd 0.34125f
C6 Iin vdd 0.78344f
C7 m4_0/a_28_n50# spike_neg 0.59813f
C8 spike spike_neg 0.77212f
C9 Iin spike_neg 0.7504f
C10 vdd.n0 vss 0.00844f
C11 vdd.n1 vss 0.00844f
C12 vdd.n2 vss 0.00409f
C13 vdd.n3 vss 0.00505f
C14 vdd.n4 vss 0.00628f
C15 vdd.n5 vss 0.01145f
C16 vdd.n7 vss 0.0381f
C17 vdd.n8 vss 0.01194f
C18 vdd.n9 vss 0.00427f
C19 vdd.n10 vss 0.00427f
C20 vdd.n11 vss 0.00427f
C21 vdd.n12 vss 0.0381f
C22 vdd.n13 vss 0.00427f
C23 vdd.n14 vss 0.00427f
C24 vdd.n15 vss 0.00427f
C25 vdd.n16 vss 0.0381f
C26 vdd.n17 vss 0.00427f
C27 vdd.n18 vss 0.01991f
C28 vdd.n19 vss 0.01183f
C29 vdd.n20 vss 0.10085f
C30 vdd.n21 vss 0.00427f
C31 vdd.n22 vss 0.01183f
C32 vdd.n23 vss 0.01218f
C33 vdd.n24 vss 0.00427f
C34 vdd.n25 vss 0.00427f
C35 vdd.n26 vss 0.01218f
C36 vdd.n27 vss 0.00427f
C37 vdd.n28 vss 0.00427f
C38 vdd.n29 vss 0.00427f
C39 vdd.n30 vss 0.00427f
C40 vdd.n31 vss 0.00628f
C41 vdd.n32 vss 0.00419f
C42 vdd.n34 vss 0.00628f
C43 vdd.n35 vss 0.00505f
C44 vdd.n36 vss 0.00419f
C45 vdd.n37 vss 0.01991f
C46 vdd.n38 vss 0.00852f
C47 vdd.n39 vss 0.01145f
C48 vdd.n40 vss 0.05659f
C49 vdd.n41 vss 0.01145f
C50 vdd.n42 vss 0.00852f
C51 vdd.n43 vss 0.00427f
C52 vdd.n44 vss 0.00427f
C53 vdd.n45 vss 0.00427f
C54 vdd.n46 vss 0.0381f
C55 vdd.n47 vss 0.0381f
C56 vdd.n48 vss 0.0381f
C57 vdd.n49 vss 0.00427f
C58 vdd.n50 vss 0.00427f
C59 vdd.n51 vss 0.00427f
C60 vdd.n52 vss 0.00427f
C61 vdd.n53 vss 0.00427f
C62 vdd.n54 vss 0.01145f
C63 vdd.n55 vss 0.05659f
C64 vdd.n56 vss 0.10085f
C65 vdd.n57 vss 0.01183f
C66 vdd.n58 vss 0.00419f
C67 vdd.n59 vss 0.27865f
C68 vdd.n60 vss 0.00844f
C69 vdd.n61 vss 0.00844f
C70 vdd.n62 vss 0.00419f
C71 vdd.n63 vss 0.01194f
C72 vdd.n65 vss 0.01145f
C73 vdd.n66 vss 0.0381f
C74 vdd.n67 vss 0.00427f
C75 vdd.n68 vss 0.00427f
C76 vdd.n69 vss 0.00427f
C77 vdd.n70 vss 0.0381f
C78 vdd.n71 vss 0.00427f
C79 vdd.n72 vss 0.00427f
C80 vdd.n73 vss 0.00427f
C81 vdd.n74 vss 0.0381f
C82 vdd.n75 vss 0.00427f
C83 vdd.n76 vss 0.01991f
C84 vdd.n77 vss 0.01183f
C85 vdd.n78 vss 0.10085f
C86 vdd.n79 vss 0.00427f
C87 vdd.n80 vss 0.01183f
C88 vdd.n81 vss 0.01218f
C89 vdd.n82 vss 0.00427f
C90 vdd.n83 vss 0.00427f
C91 vdd.n84 vss 0.01218f
C92 vdd.n85 vss 0.00427f
C93 vdd.n86 vss 0.00427f
C94 vdd.n87 vss 0.00427f
C95 vdd.n88 vss 0.00427f
C96 vdd.n89 vss 0.00628f
C97 vdd.n90 vss 0.00419f
C98 vdd.n92 vss 0.00628f
C99 vdd.n93 vss 0.00505f
C100 vdd.n94 vss 0.00419f
C101 vdd.n95 vss 0.01991f
C102 vdd.n96 vss 0.00852f
C103 vdd.n97 vss 0.01145f
C104 vdd.n98 vss 0.05659f
C105 vdd.n99 vss 0.01145f
C106 vdd.n100 vss 0.00852f
C107 vdd.n101 vss 0.00427f
C108 vdd.n102 vss 0.00427f
C109 vdd.n103 vss 0.00427f
C110 vdd.n104 vss 0.0381f
C111 vdd.n105 vss 0.0381f
C112 vdd.n106 vss 0.0381f
C113 vdd.n107 vss 0.00427f
C114 vdd.n108 vss 0.00427f
C115 vdd.n109 vss 0.00427f
C116 vdd.n110 vss 0.00427f
C117 vdd.n111 vss 0.00427f
C118 vdd.n112 vss 0.01145f
C119 vdd.n113 vss 0.05659f
C120 vdd.n114 vss 0.10085f
C121 vdd.n115 vss 0.01183f
C122 vdd.n116 vss 0.00628f
C123 vdd.n117 vss 0.00505f
C124 vdd.n118 vss 0.00409f
C125 vdd.n119 vss 0.15433f
C126 vdd.n120 vss 0.20638f
C127 vdd.n121 vss 0.00844f
C128 vdd.n122 vss 0.00844f
C129 vdd.n123 vss 0.00419f
C130 vdd.n124 vss 0.01194f
C131 vdd.n126 vss 0.01145f
C132 vdd.n127 vss 0.0381f
C133 vdd.n128 vss 0.00427f
C134 vdd.n129 vss 0.00427f
C135 vdd.n130 vss 0.00427f
C136 vdd.n131 vss 0.0381f
C137 vdd.n132 vss 0.00427f
C138 vdd.n133 vss 0.00427f
C139 vdd.n134 vss 0.00427f
C140 vdd.n135 vss 0.0381f
C141 vdd.n136 vss 0.00427f
C142 vdd.n137 vss 0.01991f
C143 vdd.n138 vss 0.01183f
C144 vdd.n139 vss 0.10085f
C145 vdd.n140 vss 0.00427f
C146 vdd.n141 vss 0.01183f
C147 vdd.n142 vss 0.01218f
C148 vdd.n143 vss 0.00427f
C149 vdd.n144 vss 0.00427f
C150 vdd.n145 vss 0.01218f
C151 vdd.n146 vss 0.00427f
C152 vdd.n147 vss 0.00427f
C153 vdd.n148 vss 0.00427f
C154 vdd.n149 vss 0.00427f
C155 vdd.n150 vss 0.00628f
C156 vdd.n151 vss 0.00419f
C157 vdd.n153 vss 0.00628f
C158 vdd.n154 vss 0.00505f
C159 vdd.n155 vss 0.00419f
C160 vdd.n156 vss 0.01991f
C161 vdd.n157 vss 0.00852f
C162 vdd.n158 vss 0.01145f
C163 vdd.n159 vss 0.05659f
C164 vdd.n160 vss 0.01145f
C165 vdd.n161 vss 0.00852f
C166 vdd.n162 vss 0.00427f
C167 vdd.n163 vss 0.00427f
C168 vdd.n164 vss 0.00427f
C169 vdd.n165 vss 0.0381f
C170 vdd.n166 vss 0.0381f
C171 vdd.n167 vss 0.0381f
C172 vdd.n168 vss 0.00427f
C173 vdd.n169 vss 0.00427f
C174 vdd.n170 vss 0.00427f
C175 vdd.n171 vss 0.00427f
C176 vdd.n172 vss 0.00427f
C177 vdd.n173 vss 0.01145f
C178 vdd.n174 vss 0.05659f
C179 vdd.n175 vss 0.10085f
C180 vdd.n176 vss 0.01183f
C181 vdd.n177 vss 0.00628f
C182 vdd.n178 vss 0.00505f
C183 vdd.n179 vss 0.00409f
C184 vdd.n180 vss 0.15433f
C185 vdd.n181 vss 0.23639f
C186 vss.n0 vss 0.00745f
C187 vss.n1 vss 0.00753f
C188 vss.n2 vss 0.00102f
C189 vss.n3 vss 0.00127f
C190 vss.n4 vss 0.00127f
C191 vss.n5 vss 0.00127f
C192 vss.n6 vss 0.00102f
C193 vss.n7 vss 0.00978f
C194 vss.n8 vss 0.00127f
C195 vss.n9 vss 0.00267f
C196 vss.n10 vss 0.0609f
C197 vss.n11 vss 0.00269f
C198 vss.n12 vss 0.1774f
C199 vss.n20 vss 0
C200 vss.n21 vss 0.00127f
C201 vss.n22 vss 0.00102f
C202 vss.n23 vss 0.00127f
C203 vss.n24 vss 0.0609f
C204 vss.n25 vss 0.00127f
C205 vss.n26 vss 0.00102f
C206 vss.n27 vss 0.00102f
C207 vss.n28 vss 0.00127f
C208 vss.n29 vss 0.00102f
C209 vss.n30 vss 0.00127f
C210 vss.n31 vss 0.0609f
C211 vss.n32 vss 0.00127f
C212 vss.n33 vss 0.00102f
C213 vss.n34 vss 0.00753f
C214 vss.n35 vss 0.00102f
C215 vss.n36 vss 0.00127f
C216 vss.n37 vss 0.0609f
C217 vss.n38 vss 0.00127f
C218 vss.n39 vss 0.00102f
C219 vss.n40 vss 0.00127f
C220 vss.n41 vss 0.00102f
C221 vss.n42 vss 0.00127f
C222 vss.n43 vss 0.0609f
C223 vss.n44 vss 0.00127f
C224 vss.n45 vss 0.00102f
C225 vss.n46 vss 0.00753f
C226 vss.n47 vss 0.00102f
C227 vss.n48 vss 0.00127f
C228 vss.n49 vss 0.0609f
C229 vss.n50 vss 0.00127f
C230 vss.n51 vss 0.00102f
C231 vss.n52 vss 0.00102f
C232 vss.n53 vss 0.00127f
C233 vss.n54 vss 0.00102f
C234 vss.n55 vss 0.00127f
C235 vss.n56 vss 0.0609f
C236 vss.n57 vss 0.00127f
C237 vss.n58 vss 0.00102f
C238 vss.n59 vss 0.00753f
C239 vss.n60 vss 0.00102f
C240 vss.n61 vss 0.00127f
C241 vss.n62 vss 0.0609f
C242 vss.n63 vss 0.00127f
C243 vss.n64 vss 0.00102f
C244 vss.n65 vss 0.00127f
C245 vss.n66 vss 0.00102f
C246 vss.n67 vss 0.00127f
C247 vss.n68 vss 0.0609f
C248 vss.n69 vss 0.00127f
C249 vss.n70 vss 0.00102f
C250 vss.n71 vss 0.00753f
C251 vss.n72 vss 0.00102f
C252 vss.n73 vss 0.00127f
C253 vss.n74 vss 0.0609f
C254 vss.n75 vss 0.00127f
C255 vss.n76 vss 0.00102f
C256 vss.n77 vss 0.00127f
C257 vss.n78 vss 0.00102f
C258 vss.n79 vss 0.00127f
C259 vss.n80 vss 0.0609f
C260 vss.n81 vss 0.00127f
C261 vss.n82 vss 0.00102f
C262 vss.n83 vss 0.00753f
C263 vss.n84 vss 0.00102f
C264 vss.n85 vss 0.00127f
C265 vss.n86 vss 0.0609f
C266 vss.n87 vss 0.00127f
C267 vss.n88 vss 0.00102f
C268 vss.n89 vss 0.00127f
C269 vss.n90 vss 0.00102f
C270 vss.n91 vss 0.00127f
C271 vss.n92 vss 0.0609f
C272 vss.n93 vss 0.00127f
C273 vss.n94 vss 0.00102f
C274 vss.n95 vss 0.00753f
C275 vss.n96 vss 0.00102f
C276 vss.n97 vss 0.00127f
C277 vss.n98 vss 0.0609f
C278 vss.n99 vss 0.00127f
C279 vss.n100 vss 0.00102f
C280 vss.n101 vss 0.00127f
C281 vss.n102 vss 0.00102f
C282 vss.n103 vss 0.00127f
C283 vss.n104 vss 0.0609f
C284 vss.n105 vss 0.00127f
C285 vss.n106 vss 0.00102f
C286 vss.n107 vss 0.00753f
C287 vss.n108 vss 0.00102f
C288 vss.n109 vss 0.00127f
C289 vss.n110 vss 0.0609f
C290 vss.n111 vss 0.00127f
C291 vss.n112 vss 0.00102f
C292 vss.n113 vss 0.00127f
C293 vss.n114 vss 0.00102f
C294 vss.n115 vss 0.00127f
C295 vss.n116 vss 0.0609f
C296 vss.n117 vss 0.00127f
C297 vss.n118 vss 0.00102f
C298 vss.n119 vss 0.00753f
C299 vss.n120 vss 0.00102f
C300 vss.n121 vss 0.00127f
C301 vss.n122 vss 0.0609f
C302 vss.n123 vss 0.00127f
C303 vss.n124 vss 0.00102f
C304 vss.n125 vss 0.00127f
C305 vss.n126 vss 0.00102f
C306 vss.n127 vss 0.00127f
C307 vss.n128 vss 0.0609f
C308 vss.n129 vss 0.00127f
C309 vss.n130 vss 0.00102f
C310 vss.n131 vss 0.00174f
C311 vss.n132 vss 0.00267f
C312 vss.n133 vss 0.36754f
C313 vss.n134 vss 0.00267f
C314 vss.n135 vss 0
C315 vss.n136 vss 0
C316 vss.n137 vss 0
C317 vss.n138 vss 0
C318 vss.n139 vss 0
C319 vss.n140 vss 0
C320 vss.n141 vss 0
C321 vss.n143 vss 0
C322 vss.n145 vss 0
C323 vss.n146 vss 0
C324 vss.n147 vss 0
C325 vss.n148 vss 0
C326 vss.n149 vss 0
C327 vss.n151 vss 0
C328 vss.n153 vss 0
C329 vss.n154 vss 0
C330 vss.n155 vss 0
C331 vss.n156 vss 0
C332 vss.n157 vss 0
C333 vss.n159 vss 0
C334 vss.n161 vss 0
C335 vss.n162 vss 0
C336 vss.n163 vss 0
C337 vss.n164 vss 0
C338 vss.n165 vss 0
C339 vss.n167 vss 0
C340 vss.n169 vss 0
C341 vss.n170 vss 0
C342 vss.n171 vss 0.00175f
C343 vss.n172 vss 0.00465f
C344 vss.n173 vss 0
C345 vss.n174 vss 0.00269f
C346 vss.n175 vss 0.09166f
C347 vss.n176 vss 0.00269f
C348 vss.n177 vss 0
C349 vss.n178 vss 0.0178f
C350 vss.n179 vss 0.00753f
C351 vss.n180 vss 0.00753f
C352 vss.n181 vss 0.00102f
C353 vss.n182 vss 0.00127f
C354 vss.n183 vss 0.0609f
C355 vss.n184 vss 0.00127f
C356 vss.n185 vss 0.00102f
C357 vss.n186 vss 0.00127f
C358 vss.n187 vss 0.00127f
C359 vss.n188 vss 0.00127f
C360 vss.n189 vss 0.00102f
C361 vss.n190 vss 0.00127f
C362 vss.n191 vss 0.0609f
C363 vss.n192 vss 0.00127f
C364 vss.n193 vss 0.00102f
C365 vss.n194 vss 0.00753f
C366 vss.n195 vss 0.00753f
C367 vss.n196 vss 0.00753f
C368 vss.n197 vss 0.00102f
C369 vss.n198 vss 0.00127f
C370 vss.n199 vss 0.0609f
C371 vss.n200 vss 0.00127f
C372 vss.n201 vss 0.00102f
C373 vss.n202 vss 0.00127f
C374 vss.n203 vss 0.00127f
C375 vss.n204 vss 0.00127f
C376 vss.n205 vss 0.00102f
C377 vss.n206 vss 0.00127f
C378 vss.n207 vss 0.0609f
C379 vss.n208 vss 0.00127f
C380 vss.n209 vss 0.00102f
C381 vss.n210 vss 0.00753f
C382 vss.n211 vss 0.00753f
C383 vss.n212 vss 0.00753f
C384 vss.n213 vss 0.00102f
C385 vss.n214 vss 0.00127f
C386 vss.n215 vss 0.0609f
C387 vss.n216 vss 0.00127f
C388 vss.n217 vss 0.00102f
C389 vss.n218 vss 0.00127f
C390 vss.n219 vss 0.00127f
C391 vss.n220 vss 0.00127f
C392 vss.n221 vss 0.00102f
C393 vss.n222 vss 0.00127f
C394 vss.n223 vss 0.0609f
C395 vss.n224 vss 0.00127f
C396 vss.n225 vss 0.00102f
C397 vss.n226 vss 0.00753f
C398 vss.n227 vss 0.00753f
C399 vss.n228 vss 0.00753f
C400 vss.n229 vss 0.00102f
C401 vss.n230 vss 0.00127f
C402 vss.n231 vss 0.0609f
C403 vss.n232 vss 0.00127f
C404 vss.n233 vss 0.00102f
C405 vss.n234 vss 0.00127f
C406 vss.n235 vss 0.00127f
C407 vss.n236 vss 0.00127f
C408 vss.n237 vss 0.00102f
C409 vss.n238 vss 0.00127f
C410 vss.n239 vss 0.0609f
C411 vss.n240 vss 0.00127f
C412 vss.n241 vss 0.00102f
C413 vss.n242 vss 0.00753f
C414 vss.n243 vss 0.00753f
C415 vss.n244 vss 0.00753f
C416 vss.n245 vss 0.00102f
C417 vss.n246 vss 0.00127f
C418 vss.n247 vss 0.0609f
C419 vss.n248 vss 0.00127f
C420 vss.n249 vss 0.00102f
C421 vss.n250 vss 0.00127f
C422 vss.n251 vss 0.00127f
C423 vss.n252 vss 0.00127f
C424 vss.n253 vss 0.00102f
C425 vss.n254 vss 0.00127f
C426 vss.n255 vss 0.0609f
C427 vss.n256 vss 0.00127f
C428 vss.n257 vss 0.00102f
C429 vss.n258 vss 0.00753f
C430 vss.n259 vss 0.00753f
C431 vss.n260 vss 0.00753f
C432 vss.n261 vss 0.00102f
C433 vss.n262 vss 0.00127f
C434 vss.n263 vss 0.0609f
C435 vss.n264 vss 0.00127f
C436 vss.n265 vss 0.00102f
C437 vss.n266 vss 0.00127f
C438 vss.n267 vss 0.00127f
C439 vss.n268 vss 0.00127f
C440 vss.n269 vss 0.00102f
C441 vss.n270 vss 0.00127f
C442 vss.n271 vss 0.0609f
C443 vss.n272 vss 0.00127f
C444 vss.n273 vss 0.00102f
C445 vss.n274 vss 0.00753f
C446 vss.n275 vss 0.00753f
C447 vss.n276 vss 0.00753f
C448 vss.n277 vss 0.00102f
C449 vss.n278 vss 0.00127f
C450 vss.n279 vss 0.0609f
C451 vss.n280 vss 0.00127f
C452 vss.n281 vss 0.00102f
C453 vss.n282 vss 0.00127f
C454 vss.n283 vss 0.00127f
C455 vss.n284 vss 0.00127f
C456 vss.n285 vss 0.00127f
C457 vss.n286 vss 0.00102f
C458 vss.n287 vss 0.00127f
C459 vss.n288 vss 0.0609f
C460 vss.n289 vss 0.00127f
C461 vss.n290 vss 0.00102f
C462 vss.n291 vss 0.00753f
C463 vss.n292 vss 0.00753f
C464 vss.n293 vss 0.00753f
C465 vss.n294 vss 0.00102f
C466 vss.n295 vss 0.00127f
C467 vss.n296 vss 0.0609f
C468 vss.n297 vss 0.00127f
C469 vss.n298 vss 0.00127f
C470 vss.n299 vss 0.00102f
C471 vss.n300 vss 0.00127f
C472 vss.n301 vss 0.00127f
C473 vss.n302 vss 0.00127f
C474 vss.n303 vss 0.00102f
C475 vss.n304 vss 0.00127f
C476 vss.n305 vss 0.0609f
C477 vss.n306 vss 0.0609f
C478 vss.n307 vss 0.00127f
C479 vss.n308 vss 0.00102f
C480 vss.n309 vss 0.00753f
C481 vss.n310 vss 0.00753f
C482 vss.n311 vss 0.00753f
C483 vss.n312 vss 0.00102f
C484 vss.n313 vss 0.00127f
C485 vss.n314 vss 0.00127f
C486 vss.n315 vss 0.0609f
C487 vss.n316 vss 0.00127f
C488 vss.n317 vss 0.00102f
C489 vss.n318 vss 0.00127f
C490 vss.n319 vss 0.00127f
C491 vss.n320 vss 0.00127f
C492 vss.n321 vss 0.00127f
C493 vss.n322 vss 0.00127f
C494 vss.n323 vss 0.00102f
C495 vss.n324 vss 0.00127f
C496 vss.n325 vss 0.0609f
C497 vss.n326 vss 0.0609f
C498 vss.n327 vss 0.00127f
C499 vss.n328 vss 0.0609f
C500 vss.n329 vss 0.00127f
C501 vss.n330 vss 0.00127f
C502 vss.n331 vss 0.00102f
C503 vss.n332 vss 0
C504 vss.n333 vss 0.00465f
C505 vss.n334 vss 0.04019f
C506 vss.n335 vss 0.00166f
C507 vss.n336 vss 0
C508 vss.n337 vss 0
C509 vss.n338 vss 0
C510 vss.n339 vss 0
C511 vss.n340 vss 0.00248f
C512 vss.n341 vss 0.04712f
C513 vss.n345 vss 0
C514 vss.n346 vss 0.00429f
C515 vss.n347 vss 0.00127f
C516 vss.n348 vss 0.00127f
C517 vss.n349 vss 0.00429f
C518 vss.n350 vss 0.00246f
C519 vss.n351 vss 0.03378f
C520 vss.n352 vss 0.13858f
C521 vss.n353 vss 0.04712f
C522 vss.n358 vss 0
C523 vss.n359 vss 0.00248f
C524 vss.n360 vss 0
C525 vss.n361 vss 0.00166f
C526 vss.n362 vss 0
C527 vss.n363 vss 0.00247f
C528 vss.n364 vss 0.00127f
C529 vss.n365 vss 0.00247f
C530 vss.n366 vss 0.23389f
C531 vss.n367 vss 0.04712f
C532 vss.n372 vss 0
C533 vss.n373 vss 0.00248f
C534 vss.n374 vss 0
C535 vss.n375 vss 0.00166f
C536 vss.n376 vss 0
C537 vss.n377 vss 0.00247f
C538 vss.n378 vss 0.00127f
C539 vss.n379 vss 0.00247f
C540 vss.n380 vss 0.00246f
C541 vss.n385 vss 0
C542 vss.n386 vss 0.00127f
C543 vss.n387 vss 0.00429f
C544 vss.n388 vss 0
C545 vss.n389 vss 0
C546 vss.n390 vss 0
C547 vss.n391 vss 0
C548 vss.n392 vss 0
C549 vss.n393 vss 0
C550 vss.n394 vss 0
C551 vss.n395 vss 0
C552 vss.n396 vss 0
C553 vss.n397 vss 0
C554 vss.n398 vss 0
C555 vss.n399 vss 0
C556 vss.n400 vss 0.00168f
C557 vss.n401 vss 0.00246f
C558 vss.n402 vss 0.00247f
C559 vss.n403 vss 0
C560 vss.n404 vss 0.00102f
C561 vss.n405 vss 0
C562 vss.n406 vss 0.00429f
C563 vss.n407 vss 0
C564 vss.n408 vss 0
C565 vss.n409 vss 0
C566 vss.n410 vss 0
C567 vss.n411 vss 0
C568 vss.n412 vss 0
C569 vss.n413 vss 0
C570 vss.n414 vss 0
C571 vss.n415 vss 0
C572 vss.n416 vss 0
C573 vss.n417 vss 0
C574 vss.n418 vss 0.00429f
C575 vss.n419 vss 0
C576 vss.n420 vss 0.00168f
C577 vss.n421 vss 0.00246f
C578 vss.n422 vss 0.26682f
C579 vss.n423 vss 0.04712f
C580 vss.n424 vss 0.03378f
C581 vss.n425 vss 0.00127f
C582 vss.n426 vss 0.00102f
C583 vss.n427 vss 0
C584 vss.n428 vss 0.05678f
C585 vss.n429 vss 0.00166f
C586 vss.n430 vss 0.00246f
C587 vss.n431 vss 0.06756f
C588 vss.n432 vss 0.10795f
C589 vss.n433 vss 0.00246f
C590 vss.n438 vss 0
C591 vss.n439 vss 0.00127f
C592 vss.n440 vss 0.00429f
C593 vss.n441 vss 0
C594 vss.n442 vss 0
C595 vss.n443 vss 0
C596 vss.n444 vss 0
C597 vss.n445 vss 0
C598 vss.n446 vss 0
C599 vss.n447 vss 0
C600 vss.n448 vss 0
C601 vss.n449 vss 0
C602 vss.n450 vss 0
C603 vss.n451 vss 0
C604 vss.n452 vss 0
C605 vss.n453 vss 0.00168f
C606 vss.n454 vss 0.00246f
C607 vss.n455 vss 0.00247f
C608 vss.n456 vss 0
C609 vss.n457 vss 0.00102f
C610 vss.n458 vss 0
C611 vss.n459 vss 0.00429f
C612 vss.n460 vss 0
C613 vss.n461 vss 0
C614 vss.n462 vss 0
C615 vss.n463 vss 0
C616 vss.n464 vss 0
C617 vss.n465 vss 0
C618 vss.n466 vss 0
C619 vss.n467 vss 0
C620 vss.n468 vss 0
C621 vss.n469 vss 0
C622 vss.n470 vss 0
C623 vss.n471 vss 0.00429f
C624 vss.n472 vss 0
C625 vss.n473 vss 0.00168f
C626 vss.n474 vss 0.00246f
C627 vss.n475 vss 0.07837f
C628 vss.n476 vss 0.04712f
C629 vss.n477 vss 0.03378f
C630 vss.n478 vss 0.00127f
C631 vss.n479 vss 0.00102f
C632 vss.n480 vss 0
C633 vss.n481 vss 0.03089f
C634 vss.n482 vss 0.00166f
C635 vss.n483 vss 0.00246f
C636 vss.n484 vss 0.06216f
C637 vss.n485 vss 0.10795f
C638 vss.n486 vss 0.08378f
C639 vss.n487 vss 0.00102f
C640 vss.n488 vss 0.00127f
C641 vss.n489 vss 0
C642 vss.n490 vss 0
C643 vss.n491 vss 0
C644 vss.n492 vss 0.00168f
C645 vss.n494 vss 0
C646 vss.n495 vss 0
C647 vss.n496 vss 0.00429f
C648 vss.n497 vss 0
C649 vss.n498 vss 0
C650 vss.n500 vss 0
C651 vss.n502 vss 0
C652 vss.n503 vss 0
C653 vss.n504 vss 0
C654 vss.n505 vss 0
C655 vss.n506 vss 0
C656 vss.n508 vss 0.00246f
C657 vss.n509 vss 0.00247f
C658 vss.n510 vss 0.04712f
C659 vss.n511 vss 0.00247f
C660 vss.n512 vss 0
C661 vss.n513 vss 0.00102f
C662 vss.n514 vss 0
C663 vss.n515 vss 0.00247f
C664 vss.n516 vss 0.00246f
C665 vss.n517 vss 0.00168f
C666 vss.n518 vss 0
C667 vss.n519 vss 0
C668 vss.n520 vss 0
C669 vss.n521 vss 0
C670 vss.n522 vss 0
C671 vss.n523 vss 0
C672 vss.n524 vss 0
C673 vss.n525 vss 0
C674 vss.n526 vss 0
C675 vss.n527 vss 0
C676 vss.n528 vss 0
C677 vss.n530 vss 0.03142f
C678 vss.n531 vss 0.00246f
C679 vss.n532 vss 0.00166f
C680 vss.n533 vss 0.03089f
C681 vss.n534 vss 0.03436f
C682 vss.n535 vss 0.0113f
C683 vss.n536 vss 0.00173f
C684 vss.n537 vss 0
C685 vss.n538 vss 0
C686 vss.n539 vss 0
C687 vss.n540 vss 0
C688 vss.n541 vss 0
C689 vss.n542 vss 0
C690 vss.n543 vss 0
C691 vss.n544 vss 0
C692 vss.n545 vss 0
C693 vss.n546 vss 0
C694 vss.n547 vss 0
C695 vss.n548 vss 0
C696 vss.n549 vss 0
C697 vss.n550 vss 0
C698 vss.n551 vss 0
C699 vss.n552 vss 0
C700 vss.n553 vss 0
C701 vss.n554 vss 0
C702 vss.n555 vss 0
C703 vss.n556 vss 0
C704 vss.n557 vss 0
C705 vss.n558 vss 0
C706 vss.n559 vss 0
C707 vss.n560 vss 0
C708 vss.n561 vss 0
C709 vss.n562 vss 0.04911f
C710 vss.n563 vss 0.0112f
C711 vss.n564 vss 0.00175f
C712 vss.n565 vss 0.00267f
C713 vss.n566 vss 0.18392f
C714 vss.n567 vss 0.09166f
C715 vss.n568 vss 0.00269f
C716 vss.n569 vss 0
C717 vss.n570 vss 0.00102f
C718 vss.n571 vss 0.00753f
C719 vss.n572 vss 0.00753f
C720 vss.n573 vss 0.00753f
C721 vss.n574 vss 0.00102f
C722 vss.n575 vss 0.00102f
C723 vss.n576 vss 0.00102f
C724 vss.n577 vss 0.00384f
C725 vss.n578 vss 0.00466f
C726 Iin.n0 vss 0.00192f
C727 Iin.n1 vss 0.00192f
C728 Iin.n2 vss 1.63193f
C729 Iin.n3 vss 0.09271f
C730 Iin.n4 vss 0.02001f
C731 spike_neg.n0 vss 0.01114f
C732 spike_neg.n1 vss 0.01504f
C733 spike_neg.n2 vss 0.01109f
C734 spike_neg.n3 vss 0.4606f
C735 spike_neg.n4 vss 0.12832f
C736 spike_neg.n5 vss 0.01109f
C737 spike_neg.n6 vss 0.3567f
C738 vdd vss -5.54167f
C739 Iin vss -1.29258f
C740 spike_neg vss -1.84963f
C741 m4_0/a_28_n50# vss 0.83392f
C742 spike vss 0.39054f
.ends
