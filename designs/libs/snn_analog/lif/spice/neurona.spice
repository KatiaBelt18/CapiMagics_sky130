* NGSPICE file created from neurona.ext - technology: sky130A

.subckt m1 w_n366_n485# a_n106_n50# a_n33_n246# a_28_n50# VSUBS
X0 a_28_n50# a_n33_n246# a_n106_n50# w_n366_n485# sky130_fd_pr__pfet_01v8 ad=0.195 pd=1.78 as=0.195 ps=1.78 w=0.5 l=0.28
C0 a_28_n50# a_n33_n246# 0.02013f
C1 a_n106_n50# a_n33_n246# 0.03602f
C2 a_28_n50# w_n366_n485# 0.23533f
C3 a_n106_n50# w_n366_n485# 0.11818f
C4 a_n33_n246# w_n366_n485# 0.27972f
C5 a_n106_n50# a_28_n50# 0.25526f
C6 a_28_n50# VSUBS 0.02584f
C7 a_n106_n50# VSUBS 0.02549f
C8 a_n33_n246# VSUBS 0.04528f
C9 w_n366_n485# VSUBS 2.6935f
.ends

.subckt cap c1_n1620_n620# m3_n1620_n620# VSUBS
X0 c1_n1620_n620# m3_n1620_n620# sky130_fd_pr__cap_mim_m3_1 l=6.2 w=16.2
C0 m3_n1620_n620# c1_n1620_n620# 7.72008f
C1 c1_n1620_n620# VSUBS 1.37315f
C2 m3_n1620_n620# VSUBS 3.07879f
.ends

.subckt m6 w_n366_n485# a_n106_n50# a_n33_n246# a_28_n50# VSUBS
X0 a_28_n50# a_n33_n246# a_n106_n50# w_n366_n485# sky130_fd_pr__pfet_01v8 ad=0.195 pd=1.78 as=0.195 ps=1.78 w=0.5 l=0.28
C0 a_n33_n246# a_n106_n50# 0.03602f
C1 w_n366_n485# a_n106_n50# 0.11818f
C2 a_n33_n246# a_28_n50# 0.02013f
C3 w_n366_n485# a_28_n50# 0.23533f
C4 a_n106_n50# a_28_n50# 0.25526f
C5 w_n366_n485# a_n33_n246# 0.27972f
C6 a_28_n50# VSUBS 0.02584f
C7 a_n106_n50# VSUBS 0.02549f
C8 a_n33_n246# VSUBS 0.04528f
C9 w_n366_n485# VSUBS 2.6935f
.ends

.subckt m4 a_n320_n439# a_n106_n50# a_n33_n246# a_28_n50#
X0 a_28_n50# a_n33_n246# a_n106_n50# a_n320_n439# sky130_fd_pr__nfet_01v8 ad=0.195 pd=1.78 as=0.195 ps=1.78 w=0.5 l=0.28
C0 a_n106_n50# a_28_n50# 0.25526f
C1 a_n33_n246# a_28_n50# 0.02013f
C2 a_n33_n246# a_n106_n50# 0.03602f
C3 a_28_n50# a_n320_n439# 0.24224f
C4 a_n106_n50# a_n320_n439# 0.1375f
C5 a_n33_n246# a_n320_n439# 0.31664f
.ends

.subckt m2 a_n320_n439# a_n106_n50# a_n33_n246# a_28_n50#
X0 a_28_n50# a_n33_n246# a_n106_n50# a_n320_n439# sky130_fd_pr__nfet_01v8 ad=0.195 pd=1.78 as=0.195 ps=1.78 w=0.5 l=0.28
C0 a_n106_n50# a_28_n50# 0.25526f
C1 a_n33_n246# a_28_n50# 0.02013f
C2 a_n33_n246# a_n106_n50# 0.03602f
C3 a_28_n50# a_n320_n439# 0.24224f
C4 a_n106_n50# a_n320_n439# 0.1375f
C5 a_n33_n246# a_n320_n439# 0.31664f
.ends

.subckt m7 a_n320_n439# a_n106_n50# a_n33_n246# a_28_n50#
X0 a_28_n50# a_n33_n246# a_n106_n50# a_n320_n439# sky130_fd_pr__nfet_01v8 ad=0.195 pd=1.78 as=0.195 ps=1.78 w=0.5 l=0.28
C0 a_n106_n50# a_28_n50# 0.25526f
C1 a_n33_n246# a_28_n50# 0.02013f
C2 a_n33_n246# a_n106_n50# 0.03602f
C3 a_28_n50# a_n320_n439# 0.24224f
C4 a_n106_n50# a_n320_n439# 0.1375f
C5 a_n33_n246# a_n320_n439# 0.31664f
.ends

.subckt m5 a_n2078_n300# a_2000_n300# a_n2292_n689# a_n2000_n496#
X0 a_2000_n300# a_n2000_n496# a_n2078_n300# a_n2292_n689# sky130_fd_pr__nfet_01v8 ad=1.17 pd=6.78 as=1.17 ps=6.78 w=3 l=20
C0 a_n2078_n300# a_2000_n300# 2.38458f
C1 a_n2000_n496# a_2000_n300# 0.33408f
C2 a_n2000_n496# a_n2078_n300# 1.30716f
C3 a_2000_n300# a_n2292_n689# 2.01201f
C4 a_n2078_n300# a_n2292_n689# 0.62236f
C5 a_n2000_n496# a_n2292_n689# 7.42062f
.ends

.subckt m3 w_n366_n485# a_n106_n50# a_n33_n246# a_28_n50# VSUBS
X0 a_28_n50# a_n33_n246# a_n106_n50# w_n366_n485# sky130_fd_pr__pfet_01v8 ad=0.195 pd=1.78 as=0.195 ps=1.78 w=0.5 l=0.28
C0 a_n33_n246# a_28_n50# 0.02013f
C1 w_n366_n485# a_28_n50# 0.23533f
C2 a_n33_n246# a_n106_n50# 0.03602f
C3 w_n366_n485# a_n106_n50# 0.11818f
C4 a_28_n50# a_n106_n50# 0.25526f
C5 w_n366_n485# a_n33_n246# 0.27972f
C6 a_28_n50# VSUBS 0.02584f
C7 a_n106_n50# VSUBS 0.02549f
C8 a_n33_n246# VSUBS 0.04528f
C9 w_n366_n485# VSUBS 2.6935f
.ends

.subckt neurona Vdd Vss Iin spike_neg spike
Xm1_0 Vdd Vdd Iin spike_neg Vss m1
Xcap_0 Iin Vss Vss cap
Xm6_0 Vdd Vdd spike_neg spike Vss m6
Xm4_0 Vss Vss spike_neg m4_0/a_28_n50# m4
Xm2_0 Vss Vss Iin spike_neg m2
Xm7_0 Vss Vss spike_neg spike m7
Xm5_0 Vss Iin Vss m4_0/a_28_n50# m5
Xm3_0 Vdd Vdd spike_neg m4_0/a_28_n50# Vss m3
R0 spike_neg.n3 spike_neg.n1 353.212
R1 spike_neg.n4 spike_neg.n0 340.985
R2 spike_neg.n6 spike_neg.n5 340.329
R3 spike_neg.n3 spike_neg.n2 340.329
R4 spike_neg spike_neg.n6 18.4787
R5 spike_neg.n6 spike_neg.n4 12.2884
R6 spike_neg.n4 spike_neg.n3 1.32247
R7 Iin.n3 Iin.n1 340.863
R8 Iin.n4 Iin.n0 340.832
R9 Iin.n3 Iin.n2 48.8568
R10 Iin.n4 Iin.n3 11.7846
R11 Iin Iin.n4 8.35936
R12 Vss.n422 Vss.n366 17344.6
R13 Vss.n485 Vss.n352 14226.7
R14 Vss.n432 Vss.n366 14226.7
R15 Vss.n366 Vss.n352 5784.46
R16 Vss.n352 Vss.n12 4943.69
R17 Vss.n174 Vss.n134 715.928
R18 Vss.n565 Vss.n11 715.928
R19 Vss.n176 Vss.n132 715.928
R20 Vss.n568 Vss.n9 715.928
R21 Vss.n486 Vss.n485 638.061
R22 Vss.n421 Vss.n379 634.245
R23 Vss.n380 Vss.n377 634.245
R24 Vss.n430 Vss.n373 634.245
R25 Vss.n402 Vss.n401 634.245
R26 Vss.n474 Vss.n365 634.245
R27 Vss.n433 Vss.n363 634.245
R28 Vss.n483 Vss.n359 634.245
R29 Vss.n455 Vss.n454 634.245
R30 Vss.n511 Vss.n350 634.245
R31 Vss.n509 Vss.n508 634.245
R32 Vss.n531 Vss.n340 634.245
R33 Vss.n516 Vss.n515 634.245
R34 Vss.n427 Vss.n373 589.749
R35 Vss.n480 Vss.n359 589.749
R36 Vss.n340 Vss.n336 589.749
R37 Vss.n512 Vss.n511 585
R38 Vss.n511 Vss.n510 585
R39 Vss.n513 Vss.n347 585
R40 Vss.n351 Vss.n347 585
R41 Vss.n515 Vss.n514 585
R42 Vss.n515 Vss.n341 585
R43 Vss.n517 Vss.n516 585
R44 Vss.n519 Vss.n518 585
R45 Vss.n521 Vss.n520 585
R46 Vss.n523 Vss.n522 585
R47 Vss.n525 Vss.n524 585
R48 Vss.n526 Vss.n345 585
R49 Vss.n528 Vss.n527 585
R50 Vss.n339 Vss.n338 585
R51 Vss.n532 Vss.n531 585
R52 Vss.n531 Vss.n530 585
R53 Vss.n508 Vss.n335 585
R54 Vss.n506 Vss.n505 585
R55 Vss.n504 Vss.n489 585
R56 Vss.n503 Vss.n502 585
R57 Vss.n500 Vss.n490 585
R58 Vss.n498 Vss.n497 585
R59 Vss.n496 Vss.n491 585
R60 Vss.n495 Vss.n494 585
R61 Vss.n492 Vss.n350 585
R62 Vss.n486 Vss.n350 585
R63 Vss.n509 Vss.n337 585
R64 Vss.n510 Vss.n509 585
R65 Vss.n488 Vss.n487 585
R66 Vss.n488 Vss.n351 585
R67 Vss.n341 Vss.n340 585
R68 Vss.n458 Vss.n365 585
R69 Vss.n476 Vss.n365 585
R70 Vss.n457 Vss.n364 585
R71 Vss.n477 Vss.n364 585
R72 Vss.n456 Vss.n455 585
R73 Vss.n455 Vss.n353 585
R74 Vss.n454 Vss.n453 585
R75 Vss.n452 Vss.n451 585
R76 Vss.n450 Vss.n449 585
R77 Vss.n448 Vss.n447 585
R78 Vss.n446 Vss.n445 585
R79 Vss.n444 Vss.n443 585
R80 Vss.n442 Vss.n441 585
R81 Vss.n360 Vss.n358 585
R82 Vss.n483 Vss.n482 585
R83 Vss.n484 Vss.n483 585
R84 Vss.n433 Vss.n361 585
R85 Vss.n461 Vss.n460 585
R86 Vss.n463 Vss.n462 585
R87 Vss.n465 Vss.n464 585
R88 Vss.n467 Vss.n466 585
R89 Vss.n469 Vss.n468 585
R90 Vss.n471 Vss.n470 585
R91 Vss.n472 Vss.n438 585
R92 Vss.n474 Vss.n473 585
R93 Vss.n475 Vss.n474 585
R94 Vss.n363 Vss.n362 585
R95 Vss.n476 Vss.n363 585
R96 Vss.n479 Vss.n478 585
R97 Vss.n478 Vss.n477 585
R98 Vss.n359 Vss.n353 585
R99 Vss.n405 Vss.n379 585
R100 Vss.n423 Vss.n379 585
R101 Vss.n404 Vss.n378 585
R102 Vss.n424 Vss.n378 585
R103 Vss.n403 Vss.n402 585
R104 Vss.n402 Vss.n367 585
R105 Vss.n401 Vss.n400 585
R106 Vss.n399 Vss.n398 585
R107 Vss.n397 Vss.n396 585
R108 Vss.n395 Vss.n394 585
R109 Vss.n393 Vss.n392 585
R110 Vss.n391 Vss.n390 585
R111 Vss.n389 Vss.n388 585
R112 Vss.n374 Vss.n372 585
R113 Vss.n430 Vss.n429 585
R114 Vss.n431 Vss.n430 585
R115 Vss.n380 Vss.n375 585
R116 Vss.n408 Vss.n407 585
R117 Vss.n410 Vss.n409 585
R118 Vss.n412 Vss.n411 585
R119 Vss.n414 Vss.n413 585
R120 Vss.n416 Vss.n415 585
R121 Vss.n418 Vss.n417 585
R122 Vss.n419 Vss.n385 585
R123 Vss.n421 Vss.n420 585
R124 Vss.n422 Vss.n421 585
R125 Vss.n377 Vss.n376 585
R126 Vss.n423 Vss.n377 585
R127 Vss.n426 Vss.n425 585
R128 Vss.n425 Vss.n424 585
R129 Vss.n373 Vss.n367 585
R130 Vss.n174 Vss.n173 585
R131 Vss.n175 Vss.n174 585
R132 Vss.n127 Vss.n126 585
R133 Vss.n128 Vss.n127 585
R134 Vss.n185 Vss.n184 585
R135 Vss.n184 Vss.n183 585
R136 Vss.n124 Vss.n123 585
R137 Vss.n123 Vss.n122 585
R138 Vss.n190 Vss.n189 585
R139 Vss.n191 Vss.n190 585
R140 Vss.n115 Vss.n114 585
R141 Vss.n116 Vss.n115 585
R142 Vss.n201 Vss.n200 585
R143 Vss.n200 Vss.n199 585
R144 Vss.n112 Vss.n111 585
R145 Vss.n111 Vss.n110 585
R146 Vss.n206 Vss.n205 585
R147 Vss.n207 Vss.n206 585
R148 Vss.n103 Vss.n102 585
R149 Vss.n104 Vss.n103 585
R150 Vss.n217 Vss.n216 585
R151 Vss.n216 Vss.n215 585
R152 Vss.n100 Vss.n99 585
R153 Vss.n99 Vss.n98 585
R154 Vss.n222 Vss.n221 585
R155 Vss.n223 Vss.n222 585
R156 Vss.n91 Vss.n90 585
R157 Vss.n92 Vss.n91 585
R158 Vss.n233 Vss.n232 585
R159 Vss.n232 Vss.n231 585
R160 Vss.n88 Vss.n87 585
R161 Vss.n87 Vss.n86 585
R162 Vss.n238 Vss.n237 585
R163 Vss.n239 Vss.n238 585
R164 Vss.n79 Vss.n78 585
R165 Vss.n80 Vss.n79 585
R166 Vss.n249 Vss.n248 585
R167 Vss.n248 Vss.n247 585
R168 Vss.n76 Vss.n75 585
R169 Vss.n75 Vss.n74 585
R170 Vss.n254 Vss.n253 585
R171 Vss.n255 Vss.n254 585
R172 Vss.n67 Vss.n66 585
R173 Vss.n68 Vss.n67 585
R174 Vss.n265 Vss.n264 585
R175 Vss.n264 Vss.n263 585
R176 Vss.n64 Vss.n63 585
R177 Vss.n63 Vss.n62 585
R178 Vss.n270 Vss.n269 585
R179 Vss.n271 Vss.n270 585
R180 Vss.n55 Vss.n54 585
R181 Vss.n56 Vss.n55 585
R182 Vss.n281 Vss.n280 585
R183 Vss.n280 Vss.n279 585
R184 Vss.n51 Vss.n50 585
R185 Vss.n50 Vss.n49 585
R186 Vss.n287 Vss.n286 585
R187 Vss.n288 Vss.n287 585
R188 Vss.n52 Vss.n42 585
R189 Vss.n43 Vss.n42 585
R190 Vss.n297 Vss.n41 585
R191 Vss.n297 Vss.n296 585
R192 Vss.n299 Vss.n298 585
R193 Vss.n298 Vss.n37 585
R194 Vss.n39 Vss.n38 585
R195 Vss.n306 Vss.n38 585
R196 Vss.n304 Vss.n303 585
R197 Vss.n305 Vss.n304 585
R198 Vss.n30 Vss.n29 585
R199 Vss.n31 Vss.n30 585
R200 Vss.n317 Vss.n316 585
R201 Vss.n316 Vss.n315 585
R202 Vss.n26 Vss.n25 585
R203 Vss.n25 Vss.n24 585
R204 Vss.n324 Vss.n323 585
R205 Vss.n325 Vss.n324 585
R206 Vss.n27 Vss.n23 585
R207 Vss.n326 Vss.n23 585
R208 Vss.n329 Vss.n22 585
R209 Vss.n329 Vss.n328 585
R210 Vss.n331 Vss.n330 585
R211 Vss.n330 Vss.n10 585
R212 Vss.n332 Vss.n11 585
R213 Vss.n567 Vss.n11 585
R214 Vss.n569 Vss.n568 585
R215 Vss.n568 Vss.n567 585
R216 Vss.n570 Vss.n8 585
R217 Vss.n10 Vss.n8 585
R218 Vss.n327 Vss.n6 585
R219 Vss.n328 Vss.n327 585
R220 Vss.n574 Vss.n5 585
R221 Vss.n326 Vss.n5 585
R222 Vss.n575 Vss.n4 585
R223 Vss.n325 Vss.n4 585
R224 Vss.n576 Vss.n3 585
R225 Vss.n24 Vss.n3 585
R226 Vss.n314 Vss.n2 585
R227 Vss.n315 Vss.n314 585
R228 Vss.n313 Vss.n312 585
R229 Vss.n313 Vss.n31 585
R230 Vss.n33 Vss.n32 585
R231 Vss.n305 Vss.n32 585
R232 Vss.n308 Vss.n307 585
R233 Vss.n307 Vss.n306 585
R234 Vss.n36 Vss.n35 585
R235 Vss.n37 Vss.n36 585
R236 Vss.n295 Vss.n294 585
R237 Vss.n296 Vss.n295 585
R238 Vss.n45 Vss.n44 585
R239 Vss.n44 Vss.n43 585
R240 Vss.n290 Vss.n289 585
R241 Vss.n289 Vss.n288 585
R242 Vss.n48 Vss.n47 585
R243 Vss.n49 Vss.n48 585
R244 Vss.n278 Vss.n277 585
R245 Vss.n279 Vss.n278 585
R246 Vss.n58 Vss.n57 585
R247 Vss.n57 Vss.n56 585
R248 Vss.n273 Vss.n272 585
R249 Vss.n272 Vss.n271 585
R250 Vss.n61 Vss.n60 585
R251 Vss.n62 Vss.n61 585
R252 Vss.n262 Vss.n261 585
R253 Vss.n263 Vss.n262 585
R254 Vss.n70 Vss.n69 585
R255 Vss.n69 Vss.n68 585
R256 Vss.n257 Vss.n256 585
R257 Vss.n256 Vss.n255 585
R258 Vss.n73 Vss.n72 585
R259 Vss.n74 Vss.n73 585
R260 Vss.n246 Vss.n245 585
R261 Vss.n247 Vss.n246 585
R262 Vss.n82 Vss.n81 585
R263 Vss.n81 Vss.n80 585
R264 Vss.n241 Vss.n240 585
R265 Vss.n240 Vss.n239 585
R266 Vss.n85 Vss.n84 585
R267 Vss.n86 Vss.n85 585
R268 Vss.n230 Vss.n229 585
R269 Vss.n231 Vss.n230 585
R270 Vss.n94 Vss.n93 585
R271 Vss.n93 Vss.n92 585
R272 Vss.n225 Vss.n224 585
R273 Vss.n224 Vss.n223 585
R274 Vss.n97 Vss.n96 585
R275 Vss.n98 Vss.n97 585
R276 Vss.n214 Vss.n213 585
R277 Vss.n215 Vss.n214 585
R278 Vss.n106 Vss.n105 585
R279 Vss.n105 Vss.n104 585
R280 Vss.n209 Vss.n208 585
R281 Vss.n208 Vss.n207 585
R282 Vss.n109 Vss.n108 585
R283 Vss.n110 Vss.n109 585
R284 Vss.n198 Vss.n197 585
R285 Vss.n199 Vss.n198 585
R286 Vss.n118 Vss.n117 585
R287 Vss.n117 Vss.n116 585
R288 Vss.n193 Vss.n192 585
R289 Vss.n192 Vss.n191 585
R290 Vss.n121 Vss.n120 585
R291 Vss.n122 Vss.n121 585
R292 Vss.n182 Vss.n181 585
R293 Vss.n183 Vss.n182 585
R294 Vss.n130 Vss.n129 585
R295 Vss.n129 Vss.n128 585
R296 Vss.n177 Vss.n176 585
R297 Vss.n176 Vss.n175 585
R298 Vss.n536 Vss.n9 585
R299 Vss.n566 Vss.n9 585
R300 Vss.n538 Vss.n537 585
R301 Vss.n540 Vss.n539 585
R302 Vss.n542 Vss.n541 585
R303 Vss.n544 Vss.n543 585
R304 Vss.n546 Vss.n545 585
R305 Vss.n548 Vss.n547 585
R306 Vss.n550 Vss.n549 585
R307 Vss.n552 Vss.n551 585
R308 Vss.n554 Vss.n553 585
R309 Vss.n556 Vss.n555 585
R310 Vss.n558 Vss.n557 585
R311 Vss.n560 Vss.n559 585
R312 Vss.n562 Vss.n561 585
R313 Vss.n563 Vss.n20 585
R314 Vss.n565 Vss.n564 585
R315 Vss.n566 Vss.n565 585
R316 Vss.n171 Vss.n134 585
R317 Vss.n170 Vss.n169 585
R318 Vss.n167 Vss.n135 585
R319 Vss.n165 Vss.n164 585
R320 Vss.n163 Vss.n136 585
R321 Vss.n162 Vss.n161 585
R322 Vss.n159 Vss.n137 585
R323 Vss.n157 Vss.n156 585
R324 Vss.n155 Vss.n138 585
R325 Vss.n154 Vss.n153 585
R326 Vss.n151 Vss.n139 585
R327 Vss.n149 Vss.n148 585
R328 Vss.n147 Vss.n140 585
R329 Vss.n146 Vss.n145 585
R330 Vss.n143 Vss.n141 585
R331 Vss.n132 Vss.n131 585
R332 Vss.n475 Vss.n432 573.652
R333 Vss.n566 Vss.n12 449.938
R334 Vss.n432 Vss.n431 444.832
R335 Vss.n485 Vss.n484 380.421
R336 Vss.n530 Vss.n341 360.293
R337 Vss.n510 Vss.n486 360.293
R338 Vss.n484 Vss.n353 360.293
R339 Vss.n476 Vss.n475 360.293
R340 Vss.n431 Vss.n367 360.293
R341 Vss.n423 Vss.n422 360.293
R342 Vss.n530 Vss.n342 256.663
R343 Vss.n530 Vss.n343 256.663
R344 Vss.n530 Vss.n344 256.663
R345 Vss.n530 Vss.n529 256.663
R346 Vss.n507 Vss.n486 256.663
R347 Vss.n501 Vss.n486 256.663
R348 Vss.n499 Vss.n486 256.663
R349 Vss.n493 Vss.n486 256.663
R350 Vss.n484 Vss.n354 256.663
R351 Vss.n484 Vss.n355 256.663
R352 Vss.n484 Vss.n356 256.663
R353 Vss.n484 Vss.n357 256.663
R354 Vss.n475 Vss.n434 256.663
R355 Vss.n475 Vss.n435 256.663
R356 Vss.n475 Vss.n436 256.663
R357 Vss.n475 Vss.n437 256.663
R358 Vss.n431 Vss.n368 256.663
R359 Vss.n431 Vss.n369 256.663
R360 Vss.n431 Vss.n370 256.663
R361 Vss.n431 Vss.n371 256.663
R362 Vss.n422 Vss.n381 256.663
R363 Vss.n422 Vss.n382 256.663
R364 Vss.n422 Vss.n383 256.663
R365 Vss.n422 Vss.n384 256.663
R366 Vss.n566 Vss.n13 256.663
R367 Vss.n566 Vss.n14 256.663
R368 Vss.n566 Vss.n15 256.663
R369 Vss.n566 Vss.n16 256.663
R370 Vss.n566 Vss.n17 256.663
R371 Vss.n566 Vss.n18 256.663
R372 Vss.n566 Vss.n19 256.663
R373 Vss.n168 Vss.n133 256.663
R374 Vss.n166 Vss.n133 256.663
R375 Vss.n160 Vss.n133 256.663
R376 Vss.n158 Vss.n133 256.663
R377 Vss.n152 Vss.n133 256.663
R378 Vss.n150 Vss.n133 256.663
R379 Vss.n144 Vss.n133 256.663
R380 Vss.n142 Vss.n133 256.663
R381 Vss.n425 Vss.n373 240.244
R382 Vss.n425 Vss.n377 240.244
R383 Vss.n402 Vss.n378 240.244
R384 Vss.n379 Vss.n378 240.244
R385 Vss.n478 Vss.n359 240.244
R386 Vss.n478 Vss.n363 240.244
R387 Vss.n455 Vss.n364 240.244
R388 Vss.n365 Vss.n364 240.244
R389 Vss.n488 Vss.n340 240.244
R390 Vss.n509 Vss.n488 240.244
R391 Vss.n515 Vss.n347 240.244
R392 Vss.n511 Vss.n347 240.244
R393 Vss.n174 Vss.n127 240.244
R394 Vss.n184 Vss.n127 240.244
R395 Vss.n184 Vss.n123 240.244
R396 Vss.n190 Vss.n123 240.244
R397 Vss.n190 Vss.n115 240.244
R398 Vss.n200 Vss.n115 240.244
R399 Vss.n200 Vss.n111 240.244
R400 Vss.n206 Vss.n111 240.244
R401 Vss.n206 Vss.n103 240.244
R402 Vss.n216 Vss.n103 240.244
R403 Vss.n216 Vss.n99 240.244
R404 Vss.n222 Vss.n99 240.244
R405 Vss.n222 Vss.n91 240.244
R406 Vss.n232 Vss.n91 240.244
R407 Vss.n232 Vss.n87 240.244
R408 Vss.n238 Vss.n87 240.244
R409 Vss.n238 Vss.n79 240.244
R410 Vss.n248 Vss.n79 240.244
R411 Vss.n248 Vss.n75 240.244
R412 Vss.n254 Vss.n75 240.244
R413 Vss.n254 Vss.n67 240.244
R414 Vss.n264 Vss.n67 240.244
R415 Vss.n264 Vss.n63 240.244
R416 Vss.n270 Vss.n63 240.244
R417 Vss.n270 Vss.n55 240.244
R418 Vss.n280 Vss.n55 240.244
R419 Vss.n280 Vss.n50 240.244
R420 Vss.n287 Vss.n50 240.244
R421 Vss.n287 Vss.n42 240.244
R422 Vss.n297 Vss.n42 240.244
R423 Vss.n298 Vss.n297 240.244
R424 Vss.n298 Vss.n38 240.244
R425 Vss.n304 Vss.n38 240.244
R426 Vss.n304 Vss.n30 240.244
R427 Vss.n316 Vss.n30 240.244
R428 Vss.n316 Vss.n25 240.244
R429 Vss.n324 Vss.n25 240.244
R430 Vss.n324 Vss.n23 240.244
R431 Vss.n329 Vss.n23 240.244
R432 Vss.n330 Vss.n329 240.244
R433 Vss.n330 Vss.n11 240.244
R434 Vss.n176 Vss.n129 240.244
R435 Vss.n182 Vss.n129 240.244
R436 Vss.n182 Vss.n121 240.244
R437 Vss.n192 Vss.n121 240.244
R438 Vss.n192 Vss.n117 240.244
R439 Vss.n198 Vss.n117 240.244
R440 Vss.n198 Vss.n109 240.244
R441 Vss.n208 Vss.n109 240.244
R442 Vss.n208 Vss.n105 240.244
R443 Vss.n214 Vss.n105 240.244
R444 Vss.n214 Vss.n97 240.244
R445 Vss.n224 Vss.n97 240.244
R446 Vss.n224 Vss.n93 240.244
R447 Vss.n230 Vss.n93 240.244
R448 Vss.n230 Vss.n85 240.244
R449 Vss.n240 Vss.n85 240.244
R450 Vss.n240 Vss.n81 240.244
R451 Vss.n246 Vss.n81 240.244
R452 Vss.n246 Vss.n73 240.244
R453 Vss.n256 Vss.n73 240.244
R454 Vss.n256 Vss.n69 240.244
R455 Vss.n262 Vss.n69 240.244
R456 Vss.n262 Vss.n61 240.244
R457 Vss.n272 Vss.n61 240.244
R458 Vss.n272 Vss.n57 240.244
R459 Vss.n278 Vss.n57 240.244
R460 Vss.n278 Vss.n48 240.244
R461 Vss.n289 Vss.n48 240.244
R462 Vss.n289 Vss.n44 240.244
R463 Vss.n295 Vss.n44 240.244
R464 Vss.n295 Vss.n36 240.244
R465 Vss.n307 Vss.n36 240.244
R466 Vss.n307 Vss.n32 240.244
R467 Vss.n313 Vss.n32 240.244
R468 Vss.n314 Vss.n313 240.244
R469 Vss.n314 Vss.n3 240.244
R470 Vss.n4 Vss.n3 240.244
R471 Vss.n5 Vss.n4 240.244
R472 Vss.n327 Vss.n5 240.244
R473 Vss.n327 Vss.n8 240.244
R474 Vss.n568 Vss.n8 240.244
R475 Vss.n175 Vss.n133 224.411
R476 Vss.n567 Vss.n566 224.411
R477 Vss.n351 Vss.n341 201.281
R478 Vss.n510 Vss.n351 201.281
R479 Vss.n477 Vss.n353 201.281
R480 Vss.n477 Vss.n476 201.281
R481 Vss.n424 Vss.n367 201.281
R482 Vss.n424 Vss.n423 201.281
R483 Vss.n421 Vss.n385 163.367
R484 Vss.n417 Vss.n416 163.367
R485 Vss.n413 Vss.n412 163.367
R486 Vss.n409 Vss.n408 163.367
R487 Vss.n398 Vss.n397 163.367
R488 Vss.n394 Vss.n393 163.367
R489 Vss.n390 Vss.n389 163.367
R490 Vss.n430 Vss.n372 163.367
R491 Vss.n474 Vss.n438 163.367
R492 Vss.n470 Vss.n469 163.367
R493 Vss.n466 Vss.n465 163.367
R494 Vss.n462 Vss.n461 163.367
R495 Vss.n451 Vss.n450 163.367
R496 Vss.n447 Vss.n446 163.367
R497 Vss.n443 Vss.n442 163.367
R498 Vss.n483 Vss.n358 163.367
R499 Vss.n494 Vss.n350 163.367
R500 Vss.n498 Vss.n491 163.367
R501 Vss.n502 Vss.n500 163.367
R502 Vss.n506 Vss.n489 163.367
R503 Vss.n520 Vss.n519 163.367
R504 Vss.n524 Vss.n523 163.367
R505 Vss.n528 Vss.n345 163.367
R506 Vss.n531 Vss.n339 163.367
R507 Vss.n169 Vss.n167 163.367
R508 Vss.n165 Vss.n136 163.367
R509 Vss.n161 Vss.n159 163.367
R510 Vss.n157 Vss.n138 163.367
R511 Vss.n153 Vss.n151 163.367
R512 Vss.n149 Vss.n140 163.367
R513 Vss.n145 Vss.n143 163.367
R514 Vss.n565 Vss.n20 163.367
R515 Vss.n561 Vss.n560 163.367
R516 Vss.n557 Vss.n556 163.367
R517 Vss.n553 Vss.n552 163.367
R518 Vss.n549 Vss.n548 163.367
R519 Vss.n545 Vss.n544 163.367
R520 Vss.n541 Vss.n540 163.367
R521 Vss.n537 Vss.n9 163.367
R522 Vss.n175 Vss.n128 111.647
R523 Vss.n183 Vss.n128 111.647
R524 Vss.n183 Vss.n122 111.647
R525 Vss.n191 Vss.n122 111.647
R526 Vss.n191 Vss.n116 111.647
R527 Vss.n199 Vss.n116 111.647
R528 Vss.n199 Vss.n110 111.647
R529 Vss.n207 Vss.n110 111.647
R530 Vss.n207 Vss.n104 111.647
R531 Vss.n215 Vss.n104 111.647
R532 Vss.n215 Vss.n98 111.647
R533 Vss.n223 Vss.n98 111.647
R534 Vss.n223 Vss.n92 111.647
R535 Vss.n231 Vss.n92 111.647
R536 Vss.n231 Vss.n86 111.647
R537 Vss.n239 Vss.n86 111.647
R538 Vss.n239 Vss.n80 111.647
R539 Vss.n247 Vss.n80 111.647
R540 Vss.n247 Vss.n74 111.647
R541 Vss.n255 Vss.n74 111.647
R542 Vss.n255 Vss.n68 111.647
R543 Vss.n263 Vss.n68 111.647
R544 Vss.n263 Vss.n62 111.647
R545 Vss.n271 Vss.n62 111.647
R546 Vss.n271 Vss.n56 111.647
R547 Vss.n279 Vss.n56 111.647
R548 Vss.n279 Vss.n49 111.647
R549 Vss.n288 Vss.n49 111.647
R550 Vss.n288 Vss.n43 111.647
R551 Vss.n296 Vss.n43 111.647
R552 Vss.n296 Vss.n37 111.647
R553 Vss.n306 Vss.n37 111.647
R554 Vss.n306 Vss.n305 111.647
R555 Vss.n305 Vss.n31 111.647
R556 Vss.n315 Vss.n31 111.647
R557 Vss.n315 Vss.n24 111.647
R558 Vss.n325 Vss.n24 111.647
R559 Vss.n326 Vss.n325 111.647
R560 Vss.n328 Vss.n326 111.647
R561 Vss.n328 Vss.n10 111.647
R562 Vss.n567 Vss.n10 111.647
R563 Vss.n417 Vss.n384 71.676
R564 Vss.n413 Vss.n383 71.676
R565 Vss.n409 Vss.n382 71.676
R566 Vss.n381 Vss.n380 71.676
R567 Vss.n401 Vss.n368 71.676
R568 Vss.n397 Vss.n369 71.676
R569 Vss.n393 Vss.n370 71.676
R570 Vss.n389 Vss.n371 71.676
R571 Vss.n470 Vss.n437 71.676
R572 Vss.n466 Vss.n436 71.676
R573 Vss.n462 Vss.n435 71.676
R574 Vss.n434 Vss.n433 71.676
R575 Vss.n454 Vss.n354 71.676
R576 Vss.n450 Vss.n355 71.676
R577 Vss.n446 Vss.n356 71.676
R578 Vss.n442 Vss.n357 71.676
R579 Vss.n493 Vss.n491 71.676
R580 Vss.n500 Vss.n499 71.676
R581 Vss.n501 Vss.n489 71.676
R582 Vss.n508 Vss.n507 71.676
R583 Vss.n516 Vss.n342 71.676
R584 Vss.n520 Vss.n343 71.676
R585 Vss.n524 Vss.n344 71.676
R586 Vss.n529 Vss.n528 71.676
R587 Vss.n519 Vss.n342 71.676
R588 Vss.n523 Vss.n343 71.676
R589 Vss.n345 Vss.n344 71.676
R590 Vss.n529 Vss.n339 71.676
R591 Vss.n507 Vss.n506 71.676
R592 Vss.n502 Vss.n501 71.676
R593 Vss.n499 Vss.n498 71.676
R594 Vss.n494 Vss.n493 71.676
R595 Vss.n451 Vss.n354 71.676
R596 Vss.n447 Vss.n355 71.676
R597 Vss.n443 Vss.n356 71.676
R598 Vss.n358 Vss.n357 71.676
R599 Vss.n461 Vss.n434 71.676
R600 Vss.n465 Vss.n435 71.676
R601 Vss.n469 Vss.n436 71.676
R602 Vss.n438 Vss.n437 71.676
R603 Vss.n398 Vss.n368 71.676
R604 Vss.n394 Vss.n369 71.676
R605 Vss.n390 Vss.n370 71.676
R606 Vss.n372 Vss.n371 71.676
R607 Vss.n408 Vss.n381 71.676
R608 Vss.n412 Vss.n382 71.676
R609 Vss.n416 Vss.n383 71.676
R610 Vss.n385 Vss.n384 71.676
R611 Vss.n168 Vss.n134 71.676
R612 Vss.n167 Vss.n166 71.676
R613 Vss.n160 Vss.n136 71.676
R614 Vss.n159 Vss.n158 71.676
R615 Vss.n152 Vss.n138 71.676
R616 Vss.n151 Vss.n150 71.676
R617 Vss.n144 Vss.n140 71.676
R618 Vss.n143 Vss.n142 71.676
R619 Vss.n561 Vss.n19 71.676
R620 Vss.n557 Vss.n18 71.676
R621 Vss.n553 Vss.n17 71.676
R622 Vss.n549 Vss.n16 71.676
R623 Vss.n545 Vss.n15 71.676
R624 Vss.n541 Vss.n14 71.676
R625 Vss.n537 Vss.n13 71.676
R626 Vss.n540 Vss.n13 71.676
R627 Vss.n544 Vss.n14 71.676
R628 Vss.n548 Vss.n15 71.676
R629 Vss.n552 Vss.n16 71.676
R630 Vss.n556 Vss.n17 71.676
R631 Vss.n560 Vss.n18 71.676
R632 Vss.n20 Vss.n19 71.676
R633 Vss.n169 Vss.n168 71.676
R634 Vss.n166 Vss.n165 71.676
R635 Vss.n161 Vss.n160 71.676
R636 Vss.n158 Vss.n157 71.676
R637 Vss.n153 Vss.n152 71.676
R638 Vss.n150 Vss.n149 71.676
R639 Vss.n145 Vss.n144 71.676
R640 Vss.n142 Vss.n132 71.676
R641 Vss.n564 Vss.n333 31.1484
R642 Vss.n172 Vss.n171 31.1484
R643 Vss.n178 Vss.n131 30.9455
R644 Vss.n536 Vss.n535 30.9045
R645 Vss.n492 Vss.n349 29.2417
R646 Vss.n420 Vss.n406 29.2417
R647 Vss.n400 Vss.n387 29.2417
R648 Vss.n473 Vss.n459 29.2417
R649 Vss.n453 Vss.n440 29.2417
R650 Vss.n517 Vss.n346 29.2417
R651 Vss.n533 Vss.n335 29.0313
R652 Vss.n428 Vss.n375 29.0313
R653 Vss.n429 Vss.n428 29.0313
R654 Vss.n481 Vss.n361 29.0313
R655 Vss.n482 Vss.n481 29.0313
R656 Vss.n533 Vss.n532 29.0313
R657 Vss.n177 Vss.n130 19.3944
R658 Vss.n181 Vss.n130 19.3944
R659 Vss.n181 Vss.n120 19.3944
R660 Vss.n193 Vss.n120 19.3944
R661 Vss.n193 Vss.n118 19.3944
R662 Vss.n197 Vss.n118 19.3944
R663 Vss.n197 Vss.n108 19.3944
R664 Vss.n209 Vss.n108 19.3944
R665 Vss.n209 Vss.n106 19.3944
R666 Vss.n213 Vss.n106 19.3944
R667 Vss.n213 Vss.n96 19.3944
R668 Vss.n225 Vss.n96 19.3944
R669 Vss.n225 Vss.n94 19.3944
R670 Vss.n229 Vss.n94 19.3944
R671 Vss.n229 Vss.n84 19.3944
R672 Vss.n241 Vss.n84 19.3944
R673 Vss.n241 Vss.n82 19.3944
R674 Vss.n245 Vss.n82 19.3944
R675 Vss.n245 Vss.n72 19.3944
R676 Vss.n257 Vss.n72 19.3944
R677 Vss.n257 Vss.n70 19.3944
R678 Vss.n261 Vss.n70 19.3944
R679 Vss.n261 Vss.n60 19.3944
R680 Vss.n273 Vss.n60 19.3944
R681 Vss.n273 Vss.n58 19.3944
R682 Vss.n277 Vss.n58 19.3944
R683 Vss.n277 Vss.n47 19.3944
R684 Vss.n290 Vss.n47 19.3944
R685 Vss.n290 Vss.n45 19.3944
R686 Vss.n294 Vss.n45 19.3944
R687 Vss.n294 Vss.n35 19.3944
R688 Vss.n308 Vss.n35 19.3944
R689 Vss.n308 Vss.n33 19.3944
R690 Vss.n312 Vss.n33 19.3944
R691 Vss.n312 Vss.n2 19.3944
R692 Vss.n576 Vss.n2 19.3944
R693 Vss.n576 Vss.n575 19.3944
R694 Vss.n575 Vss.n574 19.3944
R695 Vss.n574 Vss.n6 19.3944
R696 Vss.n570 Vss.n6 19.3944
R697 Vss.n570 Vss.n569 19.3944
R698 Vss.n487 Vss.n337 19.3944
R699 Vss.n404 Vss.n403 19.3944
R700 Vss.n405 Vss.n404 19.3944
R701 Vss.n426 Vss.n376 19.3944
R702 Vss.n457 Vss.n456 19.3944
R703 Vss.n458 Vss.n457 19.3944
R704 Vss.n479 Vss.n362 19.3944
R705 Vss.n514 Vss.n513 19.3944
R706 Vss.n513 Vss.n512 19.3944
R707 Vss.n173 Vss.n126 19.3944
R708 Vss.n185 Vss.n126 19.3944
R709 Vss.n185 Vss.n124 19.3944
R710 Vss.n189 Vss.n124 19.3944
R711 Vss.n189 Vss.n114 19.3944
R712 Vss.n201 Vss.n114 19.3944
R713 Vss.n201 Vss.n112 19.3944
R714 Vss.n205 Vss.n112 19.3944
R715 Vss.n205 Vss.n102 19.3944
R716 Vss.n217 Vss.n102 19.3944
R717 Vss.n217 Vss.n100 19.3944
R718 Vss.n221 Vss.n100 19.3944
R719 Vss.n221 Vss.n90 19.3944
R720 Vss.n233 Vss.n90 19.3944
R721 Vss.n233 Vss.n88 19.3944
R722 Vss.n237 Vss.n88 19.3944
R723 Vss.n237 Vss.n78 19.3944
R724 Vss.n249 Vss.n78 19.3944
R725 Vss.n249 Vss.n76 19.3944
R726 Vss.n253 Vss.n76 19.3944
R727 Vss.n253 Vss.n66 19.3944
R728 Vss.n265 Vss.n66 19.3944
R729 Vss.n265 Vss.n64 19.3944
R730 Vss.n269 Vss.n64 19.3944
R731 Vss.n269 Vss.n54 19.3944
R732 Vss.n281 Vss.n54 19.3944
R733 Vss.n281 Vss.n51 19.3944
R734 Vss.n286 Vss.n51 19.3944
R735 Vss.n286 Vss.n52 19.3944
R736 Vss.n52 Vss.n41 19.3944
R737 Vss.n299 Vss.n41 19.3944
R738 Vss.n299 Vss.n39 19.3944
R739 Vss.n303 Vss.n39 19.3944
R740 Vss.n303 Vss.n29 19.3944
R741 Vss.n317 Vss.n29 19.3944
R742 Vss.n317 Vss.n26 19.3944
R743 Vss.n323 Vss.n26 19.3944
R744 Vss.n323 Vss.n27 19.3944
R745 Vss.n27 Vss.n22 19.3944
R746 Vss.n331 Vss.n22 19.3944
R747 Vss.n332 Vss.n331 19.3944
R748 Vss.n530 Vss.n12 14.0902
R749 Vss.n563 Vss.n562 10.6151
R750 Vss.n495 Vss.n492 10.6151
R751 Vss.n496 Vss.n495 10.6151
R752 Vss.n497 Vss.n496 10.6151
R753 Vss.n497 Vss.n490 10.6151
R754 Vss.n503 Vss.n490 10.6151
R755 Vss.n504 Vss.n503 10.6151
R756 Vss.n505 Vss.n504 10.6151
R757 Vss.n505 Vss.n335 10.6151
R758 Vss.n420 Vss.n419 10.6151
R759 Vss.n419 Vss.n418 10.6151
R760 Vss.n418 Vss.n415 10.6151
R761 Vss.n415 Vss.n414 10.6151
R762 Vss.n414 Vss.n411 10.6151
R763 Vss.n411 Vss.n410 10.6151
R764 Vss.n410 Vss.n407 10.6151
R765 Vss.n407 Vss.n375 10.6151
R766 Vss.n400 Vss.n399 10.6151
R767 Vss.n399 Vss.n396 10.6151
R768 Vss.n396 Vss.n395 10.6151
R769 Vss.n395 Vss.n392 10.6151
R770 Vss.n392 Vss.n391 10.6151
R771 Vss.n391 Vss.n388 10.6151
R772 Vss.n388 Vss.n374 10.6151
R773 Vss.n429 Vss.n374 10.6151
R774 Vss.n473 Vss.n472 10.6151
R775 Vss.n472 Vss.n471 10.6151
R776 Vss.n471 Vss.n468 10.6151
R777 Vss.n468 Vss.n467 10.6151
R778 Vss.n467 Vss.n464 10.6151
R779 Vss.n464 Vss.n463 10.6151
R780 Vss.n463 Vss.n460 10.6151
R781 Vss.n460 Vss.n361 10.6151
R782 Vss.n453 Vss.n452 10.6151
R783 Vss.n452 Vss.n449 10.6151
R784 Vss.n449 Vss.n448 10.6151
R785 Vss.n448 Vss.n445 10.6151
R786 Vss.n445 Vss.n444 10.6151
R787 Vss.n444 Vss.n441 10.6151
R788 Vss.n441 Vss.n360 10.6151
R789 Vss.n482 Vss.n360 10.6151
R790 Vss.n518 Vss.n517 10.6151
R791 Vss.n521 Vss.n518 10.6151
R792 Vss.n522 Vss.n521 10.6151
R793 Vss.n525 Vss.n522 10.6151
R794 Vss.n526 Vss.n525 10.6151
R795 Vss.n527 Vss.n526 10.6151
R796 Vss.n527 Vss.n338 10.6151
R797 Vss.n532 Vss.n338 10.6151
R798 Vss.n564 Vss.n563 10.6151
R799 Vss.n562 Vss.n559 10.6151
R800 Vss.n559 Vss.n558 10.6151
R801 Vss.n558 Vss.n555 10.6151
R802 Vss.n555 Vss.n554 10.6151
R803 Vss.n554 Vss.n551 10.6151
R804 Vss.n551 Vss.n550 10.6151
R805 Vss.n550 Vss.n547 10.6151
R806 Vss.n547 Vss.n546 10.6151
R807 Vss.n546 Vss.n543 10.6151
R808 Vss.n543 Vss.n542 10.6151
R809 Vss.n542 Vss.n539 10.6151
R810 Vss.n539 Vss.n538 10.6151
R811 Vss.n538 Vss.n536 10.6151
R812 Vss.n171 Vss.n170 10.6151
R813 Vss.n170 Vss.n135 10.6151
R814 Vss.n164 Vss.n135 10.6151
R815 Vss.n164 Vss.n163 10.6151
R816 Vss.n163 Vss.n162 10.6151
R817 Vss.n162 Vss.n137 10.6151
R818 Vss.n156 Vss.n137 10.6151
R819 Vss.n156 Vss.n155 10.6151
R820 Vss.n155 Vss.n154 10.6151
R821 Vss.n154 Vss.n139 10.6151
R822 Vss.n148 Vss.n139 10.6151
R823 Vss.n148 Vss.n147 10.6151
R824 Vss.n147 Vss.n146 10.6151
R825 Vss.n146 Vss.n141 10.6151
R826 Vss.n141 Vss.n131 10.6151
R827 Vss Vss.n578 9.62216
R828 Vss.n404 Vss.n386 9.3005
R829 Vss.n406 Vss.n405 9.3005
R830 Vss.n403 Vss.n387 9.3005
R831 Vss.n428 Vss.n376 9.3005
R832 Vss.n457 Vss.n439 9.3005
R833 Vss.n459 Vss.n458 9.3005
R834 Vss.n456 Vss.n440 9.3005
R835 Vss.n481 Vss.n362 9.3005
R836 Vss.n533 Vss.n337 9.3005
R837 Vss.n513 Vss.n348 9.3005
R838 Vss.n512 Vss.n349 9.3005
R839 Vss.n514 Vss.n346 9.3005
R840 Vss.n173 Vss.n172 9.3005
R841 Vss.n126 Vss.n125 9.3005
R842 Vss.n186 Vss.n185 9.3005
R843 Vss.n187 Vss.n124 9.3005
R844 Vss.n189 Vss.n188 9.3005
R845 Vss.n114 Vss.n113 9.3005
R846 Vss.n202 Vss.n201 9.3005
R847 Vss.n203 Vss.n112 9.3005
R848 Vss.n205 Vss.n204 9.3005
R849 Vss.n102 Vss.n101 9.3005
R850 Vss.n218 Vss.n217 9.3005
R851 Vss.n219 Vss.n100 9.3005
R852 Vss.n221 Vss.n220 9.3005
R853 Vss.n90 Vss.n89 9.3005
R854 Vss.n234 Vss.n233 9.3005
R855 Vss.n235 Vss.n88 9.3005
R856 Vss.n237 Vss.n236 9.3005
R857 Vss.n78 Vss.n77 9.3005
R858 Vss.n250 Vss.n249 9.3005
R859 Vss.n251 Vss.n76 9.3005
R860 Vss.n253 Vss.n252 9.3005
R861 Vss.n66 Vss.n65 9.3005
R862 Vss.n266 Vss.n265 9.3005
R863 Vss.n267 Vss.n64 9.3005
R864 Vss.n269 Vss.n268 9.3005
R865 Vss.n54 Vss.n53 9.3005
R866 Vss.n282 Vss.n281 9.3005
R867 Vss.n283 Vss.n51 9.3005
R868 Vss.n286 Vss.n285 9.3005
R869 Vss.n284 Vss.n52 9.3005
R870 Vss.n41 Vss.n40 9.3005
R871 Vss.n300 Vss.n299 9.3005
R872 Vss.n301 Vss.n39 9.3005
R873 Vss.n303 Vss.n302 9.3005
R874 Vss.n29 Vss.n28 9.3005
R875 Vss.n318 Vss.n317 9.3005
R876 Vss.n319 Vss.n26 9.3005
R877 Vss.n323 Vss.n322 9.3005
R878 Vss.n321 Vss.n27 9.3005
R879 Vss.n320 Vss.n22 9.3005
R880 Vss.n331 Vss.n21 9.3005
R881 Vss.n333 Vss.n332 9.3005
R882 Vss.n179 Vss.n130 9.3005
R883 Vss.n181 Vss.n180 9.3005
R884 Vss.n120 Vss.n119 9.3005
R885 Vss.n194 Vss.n193 9.3005
R886 Vss.n195 Vss.n118 9.3005
R887 Vss.n197 Vss.n196 9.3005
R888 Vss.n108 Vss.n107 9.3005
R889 Vss.n210 Vss.n209 9.3005
R890 Vss.n211 Vss.n106 9.3005
R891 Vss.n213 Vss.n212 9.3005
R892 Vss.n96 Vss.n95 9.3005
R893 Vss.n226 Vss.n225 9.3005
R894 Vss.n227 Vss.n94 9.3005
R895 Vss.n229 Vss.n228 9.3005
R896 Vss.n84 Vss.n83 9.3005
R897 Vss.n242 Vss.n241 9.3005
R898 Vss.n243 Vss.n82 9.3005
R899 Vss.n245 Vss.n244 9.3005
R900 Vss.n72 Vss.n71 9.3005
R901 Vss.n258 Vss.n257 9.3005
R902 Vss.n259 Vss.n70 9.3005
R903 Vss.n261 Vss.n260 9.3005
R904 Vss.n60 Vss.n59 9.3005
R905 Vss.n274 Vss.n273 9.3005
R906 Vss.n275 Vss.n58 9.3005
R907 Vss.n277 Vss.n276 9.3005
R908 Vss.n47 Vss.n46 9.3005
R909 Vss.n291 Vss.n290 9.3005
R910 Vss.n292 Vss.n45 9.3005
R911 Vss.n294 Vss.n293 9.3005
R912 Vss.n35 Vss.n34 9.3005
R913 Vss.n309 Vss.n308 9.3005
R914 Vss.n310 Vss.n33 9.3005
R915 Vss.n312 Vss.n311 9.3005
R916 Vss.n2 Vss.n0 9.3005
R917 Vss.n577 Vss.n576 9.3005
R918 Vss.n575 Vss.n1 9.3005
R919 Vss.n574 Vss.n573 9.3005
R920 Vss.n572 Vss.n6 9.3005
R921 Vss.n571 Vss.n570 9.3005
R922 Vss.n569 Vss.n7 9.3005
R923 Vss.n178 Vss.n177 9.3005
R924 Vss.n487 Vss.n336 4.74817
R925 Vss.n427 Vss.n426 4.74817
R926 Vss.n480 Vss.n479 4.74817
R927 Vss.n428 Vss.n427 2.27742
R928 Vss.n481 Vss.n480 2.27742
R929 Vss.n533 Vss.n336 2.27742
R930 Vss.n428 Vss.n334 1.02663
R931 Vss.n534 Vss.n334 0.855151
R932 Vss.n535 Vss.n534 0.715616
R933 Vss.n481 Vss.n334 0.171981
R934 Vss.n534 Vss.n533 0.171981
R935 Vss.n387 Vss.n386 0.152939
R936 Vss.n406 Vss.n386 0.152939
R937 Vss.n440 Vss.n439 0.152939
R938 Vss.n459 Vss.n439 0.152939
R939 Vss.n348 Vss.n346 0.152939
R940 Vss.n349 Vss.n348 0.152939
R941 Vss.n172 Vss.n125 0.152939
R942 Vss.n186 Vss.n125 0.152939
R943 Vss.n187 Vss.n186 0.152939
R944 Vss.n188 Vss.n187 0.152939
R945 Vss.n188 Vss.n113 0.152939
R946 Vss.n202 Vss.n113 0.152939
R947 Vss.n203 Vss.n202 0.152939
R948 Vss.n204 Vss.n203 0.152939
R949 Vss.n204 Vss.n101 0.152939
R950 Vss.n218 Vss.n101 0.152939
R951 Vss.n219 Vss.n218 0.152939
R952 Vss.n220 Vss.n219 0.152939
R953 Vss.n220 Vss.n89 0.152939
R954 Vss.n234 Vss.n89 0.152939
R955 Vss.n235 Vss.n234 0.152939
R956 Vss.n236 Vss.n235 0.152939
R957 Vss.n236 Vss.n77 0.152939
R958 Vss.n250 Vss.n77 0.152939
R959 Vss.n251 Vss.n250 0.152939
R960 Vss.n252 Vss.n251 0.152939
R961 Vss.n252 Vss.n65 0.152939
R962 Vss.n266 Vss.n65 0.152939
R963 Vss.n267 Vss.n266 0.152939
R964 Vss.n268 Vss.n267 0.152939
R965 Vss.n268 Vss.n53 0.152939
R966 Vss.n282 Vss.n53 0.152939
R967 Vss.n283 Vss.n282 0.152939
R968 Vss.n285 Vss.n283 0.152939
R969 Vss.n285 Vss.n284 0.152939
R970 Vss.n284 Vss.n40 0.152939
R971 Vss.n300 Vss.n40 0.152939
R972 Vss.n301 Vss.n300 0.152939
R973 Vss.n302 Vss.n301 0.152939
R974 Vss.n302 Vss.n28 0.152939
R975 Vss.n318 Vss.n28 0.152939
R976 Vss.n319 Vss.n318 0.152939
R977 Vss.n322 Vss.n319 0.152939
R978 Vss.n322 Vss.n321 0.152939
R979 Vss.n321 Vss.n320 0.152939
R980 Vss.n320 Vss.n21 0.152939
R981 Vss.n333 Vss.n21 0.152939
R982 Vss.n535 Vss.n7 0.0415678
R983 Vss.n179 Vss.n178 0.0261674
R984 Vss.n180 Vss.n179 0.0261674
R985 Vss.n180 Vss.n119 0.0261674
R986 Vss.n194 Vss.n119 0.0261674
R987 Vss.n195 Vss.n194 0.0261674
R988 Vss.n196 Vss.n195 0.0261674
R989 Vss.n196 Vss.n107 0.0261674
R990 Vss.n210 Vss.n107 0.0261674
R991 Vss.n211 Vss.n210 0.0261674
R992 Vss.n212 Vss.n211 0.0261674
R993 Vss.n212 Vss.n95 0.0261674
R994 Vss.n226 Vss.n95 0.0261674
R995 Vss.n227 Vss.n226 0.0261674
R996 Vss.n228 Vss.n227 0.0261674
R997 Vss.n228 Vss.n83 0.0261674
R998 Vss.n242 Vss.n83 0.0261674
R999 Vss.n243 Vss.n242 0.0261674
R1000 Vss.n244 Vss.n243 0.0261674
R1001 Vss.n244 Vss.n71 0.0261674
R1002 Vss.n258 Vss.n71 0.0261674
R1003 Vss.n259 Vss.n258 0.0261674
R1004 Vss.n260 Vss.n259 0.0261674
R1005 Vss.n260 Vss.n59 0.0261674
R1006 Vss.n274 Vss.n59 0.0261674
R1007 Vss.n275 Vss.n274 0.0261674
R1008 Vss.n276 Vss.n275 0.0261674
R1009 Vss.n276 Vss.n46 0.0261674
R1010 Vss.n291 Vss.n46 0.0261674
R1011 Vss.n292 Vss.n291 0.0261674
R1012 Vss.n293 Vss.n292 0.0261674
R1013 Vss.n293 Vss.n34 0.0261674
R1014 Vss.n309 Vss.n34 0.0261674
R1015 Vss.n310 Vss.n309 0.0261674
R1016 Vss.n311 Vss.n310 0.0261674
R1017 Vss.n311 Vss.n0 0.0261674
R1018 Vss.n577 Vss.n1 0.0261674
R1019 Vss.n573 Vss.n1 0.0261674
R1020 Vss.n573 Vss.n572 0.0261674
R1021 Vss.n572 Vss.n571 0.0261674
R1022 Vss.n571 Vss.n7 0.0261674
R1023 Vss.n578 Vss.n0 0.025654
R1024 Vss.n578 Vss.n577 0.00101335
R1025 Vdd.n57 Vdd.n5 360
R1026 Vdd.n39 Vdd.n22 360
R1027 Vdd.n41 Vdd.n19 360
R1028 Vdd.n54 Vdd.n8 360
R1029 Vdd.n115 Vdd.n65 360
R1030 Vdd.n97 Vdd.n80 360
R1031 Vdd.n99 Vdd.n77 360
R1032 Vdd.n112 Vdd.n63 360
R1033 Vdd.n176 Vdd.n126 360
R1034 Vdd.n158 Vdd.n141 360
R1035 Vdd.n160 Vdd.n138 360
R1036 Vdd.n173 Vdd.n124 360
R1037 Vdd.n8 Vdd.n2 189.749
R1038 Vdd.n118 Vdd.n63 189.749
R1039 Vdd.n179 Vdd.n124 189.749
R1040 Vdd.n39 Vdd.n38 185
R1041 Vdd.n40 Vdd.n39 185
R1042 Vdd.n30 Vdd.n21 185
R1043 Vdd.n21 Vdd.n16 185
R1044 Vdd.n29 Vdd.n15 185
R1045 Vdd.n46 Vdd.n15 185
R1046 Vdd.n28 Vdd.n14 185
R1047 Vdd.n47 Vdd.n14 185
R1048 Vdd.n27 Vdd.n13 185
R1049 Vdd.n48 Vdd.n13 185
R1050 Vdd.n26 Vdd.n25 185
R1051 Vdd.n25 Vdd.n12 185
R1052 Vdd.n24 Vdd.n23 185
R1053 Vdd.n24 Vdd.n7 185
R1054 Vdd.n5 Vdd.n1 185
R1055 Vdd.n55 Vdd.n5 185
R1056 Vdd.n36 Vdd.n22 185
R1057 Vdd.n35 Vdd.n34 185
R1058 Vdd.n32 Vdd.n19 185
R1059 Vdd.n20 Vdd.n19 185
R1060 Vdd.n54 Vdd.n0 185
R1061 Vdd.n55 Vdd.n54 185
R1062 Vdd.n53 Vdd.n52 185
R1063 Vdd.n53 Vdd.n7 185
R1064 Vdd.n51 Vdd.n9 185
R1065 Vdd.n12 Vdd.n9 185
R1066 Vdd.n50 Vdd.n49 185
R1067 Vdd.n49 Vdd.n48 185
R1068 Vdd.n11 Vdd.n10 185
R1069 Vdd.n47 Vdd.n11 185
R1070 Vdd.n45 Vdd.n44 185
R1071 Vdd.n46 Vdd.n45 185
R1072 Vdd.n43 Vdd.n17 185
R1073 Vdd.n17 Vdd.n16 185
R1074 Vdd.n42 Vdd.n41 185
R1075 Vdd.n41 Vdd.n40 185
R1076 Vdd.n4 Vdd.n3 185
R1077 Vdd.n58 Vdd.n57 185
R1078 Vdd.n57 Vdd.n56 185
R1079 Vdd.n97 Vdd.n96 185
R1080 Vdd.n98 Vdd.n97 185
R1081 Vdd.n88 Vdd.n79 185
R1082 Vdd.n79 Vdd.n74 185
R1083 Vdd.n87 Vdd.n73 185
R1084 Vdd.n104 Vdd.n73 185
R1085 Vdd.n86 Vdd.n72 185
R1086 Vdd.n105 Vdd.n72 185
R1087 Vdd.n85 Vdd.n71 185
R1088 Vdd.n106 Vdd.n71 185
R1089 Vdd.n84 Vdd.n83 185
R1090 Vdd.n83 Vdd.n70 185
R1091 Vdd.n82 Vdd.n81 185
R1092 Vdd.n82 Vdd.n66 185
R1093 Vdd.n65 Vdd.n61 185
R1094 Vdd.n113 Vdd.n65 185
R1095 Vdd.n94 Vdd.n80 185
R1096 Vdd.n93 Vdd.n92 185
R1097 Vdd.n90 Vdd.n77 185
R1098 Vdd.n78 Vdd.n77 185
R1099 Vdd.n112 Vdd.n60 185
R1100 Vdd.n113 Vdd.n112 185
R1101 Vdd.n111 Vdd.n110 185
R1102 Vdd.n111 Vdd.n66 185
R1103 Vdd.n109 Vdd.n67 185
R1104 Vdd.n70 Vdd.n67 185
R1105 Vdd.n108 Vdd.n107 185
R1106 Vdd.n107 Vdd.n106 185
R1107 Vdd.n69 Vdd.n68 185
R1108 Vdd.n105 Vdd.n69 185
R1109 Vdd.n103 Vdd.n102 185
R1110 Vdd.n104 Vdd.n103 185
R1111 Vdd.n101 Vdd.n75 185
R1112 Vdd.n75 Vdd.n74 185
R1113 Vdd.n100 Vdd.n99 185
R1114 Vdd.n99 Vdd.n98 185
R1115 Vdd.n115 Vdd.n62 185
R1116 Vdd.n115 Vdd.n114 185
R1117 Vdd.n117 Vdd.n116 185
R1118 Vdd.n158 Vdd.n157 185
R1119 Vdd.n159 Vdd.n158 185
R1120 Vdd.n149 Vdd.n140 185
R1121 Vdd.n140 Vdd.n135 185
R1122 Vdd.n148 Vdd.n134 185
R1123 Vdd.n165 Vdd.n134 185
R1124 Vdd.n147 Vdd.n133 185
R1125 Vdd.n166 Vdd.n133 185
R1126 Vdd.n146 Vdd.n132 185
R1127 Vdd.n167 Vdd.n132 185
R1128 Vdd.n145 Vdd.n144 185
R1129 Vdd.n144 Vdd.n131 185
R1130 Vdd.n143 Vdd.n142 185
R1131 Vdd.n143 Vdd.n127 185
R1132 Vdd.n126 Vdd.n122 185
R1133 Vdd.n174 Vdd.n126 185
R1134 Vdd.n155 Vdd.n141 185
R1135 Vdd.n154 Vdd.n153 185
R1136 Vdd.n151 Vdd.n138 185
R1137 Vdd.n139 Vdd.n138 185
R1138 Vdd.n173 Vdd.n121 185
R1139 Vdd.n174 Vdd.n173 185
R1140 Vdd.n172 Vdd.n171 185
R1141 Vdd.n172 Vdd.n127 185
R1142 Vdd.n170 Vdd.n128 185
R1143 Vdd.n131 Vdd.n128 185
R1144 Vdd.n169 Vdd.n168 185
R1145 Vdd.n168 Vdd.n167 185
R1146 Vdd.n130 Vdd.n129 185
R1147 Vdd.n166 Vdd.n130 185
R1148 Vdd.n164 Vdd.n163 185
R1149 Vdd.n165 Vdd.n164 185
R1150 Vdd.n162 Vdd.n136 185
R1151 Vdd.n136 Vdd.n135 185
R1152 Vdd.n161 Vdd.n160 185
R1153 Vdd.n160 Vdd.n159 185
R1154 Vdd.n176 Vdd.n123 185
R1155 Vdd.n176 Vdd.n175 185
R1156 Vdd.n178 Vdd.n177 185
R1157 Vdd.n56 Vdd.n55 173.907
R1158 Vdd.n40 Vdd.n20 173.907
R1159 Vdd.n114 Vdd.n113 173.907
R1160 Vdd.n98 Vdd.n78 173.907
R1161 Vdd.n175 Vdd.n174 173.907
R1162 Vdd.n159 Vdd.n139 173.907
R1163 Vdd.n34 Vdd.n19 146.341
R1164 Vdd.n57 Vdd.n4 146.341
R1165 Vdd.n92 Vdd.n77 146.341
R1166 Vdd.n116 Vdd.n115 146.341
R1167 Vdd.n153 Vdd.n138 146.341
R1168 Vdd.n177 Vdd.n176 146.341
R1169 Vdd.n24 Vdd.n5 99.5127
R1170 Vdd.n25 Vdd.n24 99.5127
R1171 Vdd.n25 Vdd.n13 99.5127
R1172 Vdd.n14 Vdd.n13 99.5127
R1173 Vdd.n15 Vdd.n14 99.5127
R1174 Vdd.n21 Vdd.n15 99.5127
R1175 Vdd.n39 Vdd.n21 99.5127
R1176 Vdd.n54 Vdd.n53 99.5127
R1177 Vdd.n53 Vdd.n9 99.5127
R1178 Vdd.n49 Vdd.n9 99.5127
R1179 Vdd.n49 Vdd.n11 99.5127
R1180 Vdd.n45 Vdd.n11 99.5127
R1181 Vdd.n45 Vdd.n17 99.5127
R1182 Vdd.n41 Vdd.n17 99.5127
R1183 Vdd.n82 Vdd.n65 99.5127
R1184 Vdd.n83 Vdd.n82 99.5127
R1185 Vdd.n83 Vdd.n71 99.5127
R1186 Vdd.n72 Vdd.n71 99.5127
R1187 Vdd.n73 Vdd.n72 99.5127
R1188 Vdd.n79 Vdd.n73 99.5127
R1189 Vdd.n97 Vdd.n79 99.5127
R1190 Vdd.n112 Vdd.n111 99.5127
R1191 Vdd.n111 Vdd.n67 99.5127
R1192 Vdd.n107 Vdd.n67 99.5127
R1193 Vdd.n107 Vdd.n69 99.5127
R1194 Vdd.n103 Vdd.n69 99.5127
R1195 Vdd.n103 Vdd.n75 99.5127
R1196 Vdd.n99 Vdd.n75 99.5127
R1197 Vdd.n143 Vdd.n126 99.5127
R1198 Vdd.n144 Vdd.n143 99.5127
R1199 Vdd.n144 Vdd.n132 99.5127
R1200 Vdd.n133 Vdd.n132 99.5127
R1201 Vdd.n134 Vdd.n133 99.5127
R1202 Vdd.n140 Vdd.n134 99.5127
R1203 Vdd.n158 Vdd.n140 99.5127
R1204 Vdd.n173 Vdd.n172 99.5127
R1205 Vdd.n172 Vdd.n128 99.5127
R1206 Vdd.n168 Vdd.n128 99.5127
R1207 Vdd.n168 Vdd.n130 99.5127
R1208 Vdd.n164 Vdd.n130 99.5127
R1209 Vdd.n164 Vdd.n136 99.5127
R1210 Vdd.n160 Vdd.n136 99.5127
R1211 Vdd.n55 Vdd.n7 88.2519
R1212 Vdd.n12 Vdd.n7 88.2519
R1213 Vdd.n48 Vdd.n12 88.2519
R1214 Vdd.n48 Vdd.n47 88.2519
R1215 Vdd.n47 Vdd.n46 88.2519
R1216 Vdd.n46 Vdd.n16 88.2519
R1217 Vdd.n40 Vdd.n16 88.2519
R1218 Vdd.n113 Vdd.n66 88.2519
R1219 Vdd.n70 Vdd.n66 88.2519
R1220 Vdd.n106 Vdd.n70 88.2519
R1221 Vdd.n106 Vdd.n105 88.2519
R1222 Vdd.n105 Vdd.n104 88.2519
R1223 Vdd.n104 Vdd.n74 88.2519
R1224 Vdd.n98 Vdd.n74 88.2519
R1225 Vdd.n174 Vdd.n127 88.2519
R1226 Vdd.n131 Vdd.n127 88.2519
R1227 Vdd.n167 Vdd.n131 88.2519
R1228 Vdd.n167 Vdd.n166 88.2519
R1229 Vdd.n166 Vdd.n165 88.2519
R1230 Vdd.n165 Vdd.n135 88.2519
R1231 Vdd.n159 Vdd.n135 88.2519
R1232 Vdd.n33 Vdd.n20 66.2847
R1233 Vdd.n56 Vdd.n6 66.2847
R1234 Vdd.n91 Vdd.n78 66.2847
R1235 Vdd.n114 Vdd.n64 66.2847
R1236 Vdd.n152 Vdd.n139 66.2847
R1237 Vdd.n175 Vdd.n125 66.2847
R1238 Vdd.n33 Vdd.n22 52.4337
R1239 Vdd.n34 Vdd.n33 52.4337
R1240 Vdd.n6 Vdd.n4 52.4337
R1241 Vdd.n8 Vdd.n6 52.4337
R1242 Vdd.n91 Vdd.n80 52.4337
R1243 Vdd.n92 Vdd.n91 52.4337
R1244 Vdd.n116 Vdd.n64 52.4337
R1245 Vdd.n64 Vdd.n63 52.4337
R1246 Vdd.n152 Vdd.n141 52.4337
R1247 Vdd.n153 Vdd.n152 52.4337
R1248 Vdd.n177 Vdd.n125 52.4337
R1249 Vdd.n125 Vdd.n124 52.4337
R1250 Vdd.n42 Vdd.n18 30.4508
R1251 Vdd.n38 Vdd.n37 30.4508
R1252 Vdd.n100 Vdd.n76 30.4508
R1253 Vdd.n96 Vdd.n95 30.4508
R1254 Vdd.n161 Vdd.n137 30.4508
R1255 Vdd.n157 Vdd.n156 30.4508
R1256 Vdd.n59 Vdd.n0 30.2801
R1257 Vdd.n59 Vdd.n1 30.2801
R1258 Vdd.n119 Vdd.n60 30.2801
R1259 Vdd.n119 Vdd.n61 30.2801
R1260 Vdd.n180 Vdd.n121 30.2801
R1261 Vdd.n180 Vdd.n122 30.2801
R1262 Vdd.n35 Vdd.n32 19.3944
R1263 Vdd.n36 Vdd.n35 19.3944
R1264 Vdd.n58 Vdd.n3 19.3944
R1265 Vdd.n93 Vdd.n90 19.3944
R1266 Vdd.n94 Vdd.n93 19.3944
R1267 Vdd.n117 Vdd.n62 19.3944
R1268 Vdd.n154 Vdd.n151 19.3944
R1269 Vdd.n155 Vdd.n154 19.3944
R1270 Vdd.n178 Vdd.n123 19.3944
R1271 Vdd Vdd.n181 13.1519
R1272 Vdd.n52 Vdd.n0 10.6151
R1273 Vdd.n52 Vdd.n51 10.6151
R1274 Vdd.n51 Vdd.n50 10.6151
R1275 Vdd.n50 Vdd.n10 10.6151
R1276 Vdd.n44 Vdd.n10 10.6151
R1277 Vdd.n44 Vdd.n43 10.6151
R1278 Vdd.n43 Vdd.n42 10.6151
R1279 Vdd.n23 Vdd.n1 10.6151
R1280 Vdd.n26 Vdd.n23 10.6151
R1281 Vdd.n27 Vdd.n26 10.6151
R1282 Vdd.n28 Vdd.n27 10.6151
R1283 Vdd.n29 Vdd.n28 10.6151
R1284 Vdd.n30 Vdd.n29 10.6151
R1285 Vdd.n38 Vdd.n30 10.6151
R1286 Vdd.n110 Vdd.n60 10.6151
R1287 Vdd.n110 Vdd.n109 10.6151
R1288 Vdd.n109 Vdd.n108 10.6151
R1289 Vdd.n108 Vdd.n68 10.6151
R1290 Vdd.n102 Vdd.n68 10.6151
R1291 Vdd.n102 Vdd.n101 10.6151
R1292 Vdd.n101 Vdd.n100 10.6151
R1293 Vdd.n81 Vdd.n61 10.6151
R1294 Vdd.n84 Vdd.n81 10.6151
R1295 Vdd.n85 Vdd.n84 10.6151
R1296 Vdd.n86 Vdd.n85 10.6151
R1297 Vdd.n87 Vdd.n86 10.6151
R1298 Vdd.n88 Vdd.n87 10.6151
R1299 Vdd.n96 Vdd.n88 10.6151
R1300 Vdd.n171 Vdd.n121 10.6151
R1301 Vdd.n171 Vdd.n170 10.6151
R1302 Vdd.n170 Vdd.n169 10.6151
R1303 Vdd.n169 Vdd.n129 10.6151
R1304 Vdd.n163 Vdd.n129 10.6151
R1305 Vdd.n163 Vdd.n162 10.6151
R1306 Vdd.n162 Vdd.n161 10.6151
R1307 Vdd.n142 Vdd.n122 10.6151
R1308 Vdd.n145 Vdd.n142 10.6151
R1309 Vdd.n146 Vdd.n145 10.6151
R1310 Vdd.n147 Vdd.n146 10.6151
R1311 Vdd.n148 Vdd.n147 10.6151
R1312 Vdd.n149 Vdd.n148 10.6151
R1313 Vdd.n157 Vdd.n149 10.6151
R1314 Vdd.n35 Vdd.n31 9.3005
R1315 Vdd.n37 Vdd.n36 9.3005
R1316 Vdd.n32 Vdd.n18 9.3005
R1317 Vdd.n59 Vdd.n58 9.3005
R1318 Vdd.n93 Vdd.n89 9.3005
R1319 Vdd.n95 Vdd.n94 9.3005
R1320 Vdd.n90 Vdd.n76 9.3005
R1321 Vdd.n119 Vdd.n62 9.3005
R1322 Vdd.n154 Vdd.n150 9.3005
R1323 Vdd.n156 Vdd.n155 9.3005
R1324 Vdd.n151 Vdd.n137 9.3005
R1325 Vdd.n180 Vdd.n123 9.3005
R1326 Vdd.n3 Vdd.n2 4.74817
R1327 Vdd.n118 Vdd.n117 4.74817
R1328 Vdd.n179 Vdd.n178 4.74817
R1329 Vdd.n59 Vdd.n2 2.27742
R1330 Vdd.n119 Vdd.n118 2.27742
R1331 Vdd.n180 Vdd.n179 2.27742
R1332 Vdd.n120 Vdd.n59 1.10474
R1333 Vdd.n181 Vdd.n120 0.884221
R1334 Vdd.n120 Vdd.n119 0.221019
R1335 Vdd.n181 Vdd.n180 0.221019
R1336 Vdd.n31 Vdd.n18 0.152939
R1337 Vdd.n37 Vdd.n31 0.152939
R1338 Vdd.n89 Vdd.n76 0.152939
R1339 Vdd.n95 Vdd.n89 0.152939
R1340 Vdd.n150 Vdd.n137 0.152939
R1341 Vdd.n156 Vdd.n150 0.152939
C0 Vdd m4_0/a_28_n50# 0.35208f
C1 spike_neg Iin 0.88245f
C2 spike_neg spike 0.89292f
C3 spike_neg Vdd 1.24761f
C4 Iin spike 0.4587f
C5 Iin Vdd 1.33269f
C6 spike_neg m4_0/a_28_n50# 0.59813f
C7 Vdd spike 0.34561f
C8 Iin m4_0/a_28_n50# 0.30496f
C9 spike m4_0/a_28_n50# 0.05098f
C10 Vdd.n0 Vss 0.00419f
C11 Vdd.n1 Vss 0.00419f
C12 Vdd.n2 Vss 0.00203f
C13 Vdd.n3 Vss 0.00251f
C14 Vdd.n4 Vss 0.00311f
C15 Vdd.n5 Vss 0.00568f
C16 Vdd.n7 Vss 0.01891f
C17 Vdd.n8 Vss 0.00592f
C18 Vdd.n9 Vss 0.00212f
C19 Vdd.n10 Vss 0.00212f
C20 Vdd.n11 Vss 0.00212f
C21 Vdd.n12 Vss 0.01891f
C22 Vdd.n13 Vss 0.00212f
C23 Vdd.n14 Vss 0.00212f
C24 Vdd.n15 Vss 0.00212f
C25 Vdd.n16 Vss 0.01891f
C26 Vdd.n17 Vss 0.00212f
C27 Vdd.n18 Vss 0.00988f
C28 Vdd.n19 Vss 0.00587f
C29 Vdd.n20 Vss 0.05005f
C30 Vdd.n21 Vss 0.00212f
C31 Vdd.n22 Vss 0.00587f
C32 Vdd.n23 Vss 0.00605f
C33 Vdd.n24 Vss 0.00212f
C34 Vdd.n25 Vss 0.00212f
C35 Vdd.n26 Vss 0.00605f
C36 Vdd.n27 Vss 0.00212f
C37 Vdd.n28 Vss 0.00212f
C38 Vdd.n29 Vss 0.00212f
C39 Vdd.n30 Vss 0.00212f
C40 Vdd.n31 Vss 0.00311f
C41 Vdd.n32 Vss 0.00208f
C42 Vdd.n34 Vss 0.00311f
C43 Vdd.n35 Vss 0.00251f
C44 Vdd.n36 Vss 0.00208f
C45 Vdd.n37 Vss 0.00988f
C46 Vdd.n38 Vss 0.00423f
C47 Vdd.n39 Vss 0.00568f
C48 Vdd.n40 Vss 0.02808f
C49 Vdd.n41 Vss 0.00568f
C50 Vdd.n42 Vss 0.00423f
C51 Vdd.n43 Vss 0.00212f
C52 Vdd.n44 Vss 0.00212f
C53 Vdd.n45 Vss 0.00212f
C54 Vdd.n46 Vss 0.01891f
C55 Vdd.n47 Vss 0.01891f
C56 Vdd.n48 Vss 0.01891f
C57 Vdd.n49 Vss 0.00212f
C58 Vdd.n50 Vss 0.00212f
C59 Vdd.n51 Vss 0.00212f
C60 Vdd.n52 Vss 0.00212f
C61 Vdd.n53 Vss 0.00212f
C62 Vdd.n54 Vss 0.00568f
C63 Vdd.n55 Vss 0.02808f
C64 Vdd.n56 Vss 0.05005f
C65 Vdd.n57 Vss 0.00587f
C66 Vdd.n58 Vss 0.00208f
C67 Vdd.n59 Vss 0.13828f
C68 Vdd.n60 Vss 0.00419f
C69 Vdd.n61 Vss 0.00419f
C70 Vdd.n62 Vss 0.00208f
C71 Vdd.n63 Vss 0.00592f
C72 Vdd.n65 Vss 0.00568f
C73 Vdd.n66 Vss 0.01891f
C74 Vdd.n67 Vss 0.00212f
C75 Vdd.n68 Vss 0.00212f
C76 Vdd.n69 Vss 0.00212f
C77 Vdd.n70 Vss 0.01891f
C78 Vdd.n71 Vss 0.00212f
C79 Vdd.n72 Vss 0.00212f
C80 Vdd.n73 Vss 0.00212f
C81 Vdd.n74 Vss 0.01891f
C82 Vdd.n75 Vss 0.00212f
C83 Vdd.n76 Vss 0.00988f
C84 Vdd.n77 Vss 0.00587f
C85 Vdd.n78 Vss 0.05005f
C86 Vdd.n79 Vss 0.00212f
C87 Vdd.n80 Vss 0.00587f
C88 Vdd.n81 Vss 0.00605f
C89 Vdd.n82 Vss 0.00212f
C90 Vdd.n83 Vss 0.00212f
C91 Vdd.n84 Vss 0.00605f
C92 Vdd.n85 Vss 0.00212f
C93 Vdd.n86 Vss 0.00212f
C94 Vdd.n87 Vss 0.00212f
C95 Vdd.n88 Vss 0.00212f
C96 Vdd.n89 Vss 0.00311f
C97 Vdd.n90 Vss 0.00208f
C98 Vdd.n92 Vss 0.00311f
C99 Vdd.n93 Vss 0.00251f
C100 Vdd.n94 Vss 0.00208f
C101 Vdd.n95 Vss 0.00988f
C102 Vdd.n96 Vss 0.00423f
C103 Vdd.n97 Vss 0.00568f
C104 Vdd.n98 Vss 0.02808f
C105 Vdd.n99 Vss 0.00568f
C106 Vdd.n100 Vss 0.00423f
C107 Vdd.n101 Vss 0.00212f
C108 Vdd.n102 Vss 0.00212f
C109 Vdd.n103 Vss 0.00212f
C110 Vdd.n104 Vss 0.01891f
C111 Vdd.n105 Vss 0.01891f
C112 Vdd.n106 Vss 0.01891f
C113 Vdd.n107 Vss 0.00212f
C114 Vdd.n108 Vss 0.00212f
C115 Vdd.n109 Vss 0.00212f
C116 Vdd.n110 Vss 0.00212f
C117 Vdd.n111 Vss 0.00212f
C118 Vdd.n112 Vss 0.00568f
C119 Vdd.n113 Vss 0.02808f
C120 Vdd.n114 Vss 0.05005f
C121 Vdd.n115 Vss 0.00587f
C122 Vdd.n116 Vss 0.00311f
C123 Vdd.n117 Vss 0.00251f
C124 Vdd.n118 Vss 0.00203f
C125 Vdd.n119 Vss 0.07659f
C126 Vdd.n120 Vss 0.10242f
C127 Vdd.n121 Vss 0.00419f
C128 Vdd.n122 Vss 0.00419f
C129 Vdd.n123 Vss 0.00208f
C130 Vdd.n124 Vss 0.00592f
C131 Vdd.n126 Vss 0.00568f
C132 Vdd.n127 Vss 0.01891f
C133 Vdd.n128 Vss 0.00212f
C134 Vdd.n129 Vss 0.00212f
C135 Vdd.n130 Vss 0.00212f
C136 Vdd.n131 Vss 0.01891f
C137 Vdd.n132 Vss 0.00212f
C138 Vdd.n133 Vss 0.00212f
C139 Vdd.n134 Vss 0.00212f
C140 Vdd.n135 Vss 0.01891f
C141 Vdd.n136 Vss 0.00212f
C142 Vdd.n137 Vss 0.00988f
C143 Vdd.n138 Vss 0.00587f
C144 Vdd.n139 Vss 0.05005f
C145 Vdd.n140 Vss 0.00212f
C146 Vdd.n141 Vss 0.00587f
C147 Vdd.n142 Vss 0.00605f
C148 Vdd.n143 Vss 0.00212f
C149 Vdd.n144 Vss 0.00212f
C150 Vdd.n145 Vss 0.00605f
C151 Vdd.n146 Vss 0.00212f
C152 Vdd.n147 Vss 0.00212f
C153 Vdd.n148 Vss 0.00212f
C154 Vdd.n149 Vss 0.00212f
C155 Vdd.n150 Vss 0.00311f
C156 Vdd.n151 Vss 0.00208f
C157 Vdd.n153 Vss 0.00311f
C158 Vdd.n154 Vss 0.00251f
C159 Vdd.n155 Vss 0.00208f
C160 Vdd.n156 Vss 0.00988f
C161 Vdd.n157 Vss 0.00423f
C162 Vdd.n158 Vss 0.00568f
C163 Vdd.n159 Vss 0.02808f
C164 Vdd.n160 Vss 0.00568f
C165 Vdd.n161 Vss 0.00423f
C166 Vdd.n162 Vss 0.00212f
C167 Vdd.n163 Vss 0.00212f
C168 Vdd.n164 Vss 0.00212f
C169 Vdd.n165 Vss 0.01891f
C170 Vdd.n166 Vss 0.01891f
C171 Vdd.n167 Vss 0.01891f
C172 Vdd.n168 Vss 0.00212f
C173 Vdd.n169 Vss 0.00212f
C174 Vdd.n170 Vss 0.00212f
C175 Vdd.n171 Vss 0.00212f
C176 Vdd.n172 Vss 0.00212f
C177 Vdd.n173 Vss 0.00568f
C178 Vdd.n174 Vss 0.02808f
C179 Vdd.n175 Vss 0.05005f
C180 Vdd.n176 Vss 0.00587f
C181 Vdd.n177 Vss 0.00311f
C182 Vdd.n178 Vss 0.00251f
C183 Vdd.n179 Vss 0.00203f
C184 Vdd.n180 Vss 0.07659f
C185 Vdd.n181 Vss 0.12811f
C186 Vss.n0 Vss 0.00656f
C187 Vss.n1 Vss 0.00663f
C188 Vss.n2 Vss 0
C189 Vss.n3 Vss 0.00112f
C190 Vss.n4 Vss 0.00112f
C191 Vss.n5 Vss 0.00112f
C192 Vss.n6 Vss 0
C193 Vss.n7 Vss 0.00862f
C194 Vss.n8 Vss 0.00112f
C195 Vss.n9 Vss 0.00235f
C196 Vss.n10 Vss 0.05364f
C197 Vss.n11 Vss 0.00237f
C198 Vss.n12 Vss 0.15623f
C199 Vss.n20 Vss 0
C200 Vss.n21 Vss 0.00112f
C201 Vss.n22 Vss 0
C202 Vss.n23 Vss 0.00112f
C203 Vss.n24 Vss 0.05364f
C204 Vss.n25 Vss 0.00112f
C205 Vss.n26 Vss 0
C206 Vss.n27 Vss 0
C207 Vss.n28 Vss 0.00112f
C208 Vss.n29 Vss 0
C209 Vss.n30 Vss 0.00112f
C210 Vss.n31 Vss 0.05364f
C211 Vss.n32 Vss 0.00112f
C212 Vss.n33 Vss 0
C213 Vss.n34 Vss 0.00663f
C214 Vss.n35 Vss 0
C215 Vss.n36 Vss 0.00112f
C216 Vss.n37 Vss 0.05364f
C217 Vss.n38 Vss 0.00112f
C218 Vss.n39 Vss 0
C219 Vss.n40 Vss 0.00112f
C220 Vss.n41 Vss 0
C221 Vss.n42 Vss 0.00112f
C222 Vss.n43 Vss 0.05364f
C223 Vss.n44 Vss 0.00112f
C224 Vss.n45 Vss 0
C225 Vss.n46 Vss 0.00663f
C226 Vss.n47 Vss 0
C227 Vss.n48 Vss 0.00112f
C228 Vss.n49 Vss 0.05364f
C229 Vss.n50 Vss 0.00112f
C230 Vss.n51 Vss 0
C231 Vss.n52 Vss 0
C232 Vss.n53 Vss 0.00112f
C233 Vss.n54 Vss 0
C234 Vss.n55 Vss 0.00112f
C235 Vss.n56 Vss 0.05364f
C236 Vss.n57 Vss 0.00112f
C237 Vss.n58 Vss 0
C238 Vss.n59 Vss 0.00663f
C239 Vss.n60 Vss 0
C240 Vss.n61 Vss 0.00112f
C241 Vss.n62 Vss 0.05364f
C242 Vss.n63 Vss 0.00112f
C243 Vss.n64 Vss 0
C244 Vss.n65 Vss 0.00112f
C245 Vss.n66 Vss 0
C246 Vss.n67 Vss 0.00112f
C247 Vss.n68 Vss 0.05364f
C248 Vss.n69 Vss 0.00112f
C249 Vss.n70 Vss 0
C250 Vss.n71 Vss 0.00663f
C251 Vss.n72 Vss 0
C252 Vss.n73 Vss 0.00112f
C253 Vss.n74 Vss 0.05364f
C254 Vss.n75 Vss 0.00112f
C255 Vss.n76 Vss 0
C256 Vss.n77 Vss 0.00112f
C257 Vss.n78 Vss 0
C258 Vss.n79 Vss 0.00112f
C259 Vss.n80 Vss 0.05364f
C260 Vss.n81 Vss 0.00112f
C261 Vss.n82 Vss 0
C262 Vss.n83 Vss 0.00663f
C263 Vss.n84 Vss 0
C264 Vss.n85 Vss 0.00112f
C265 Vss.n86 Vss 0.05364f
C266 Vss.n87 Vss 0.00112f
C267 Vss.n88 Vss 0
C268 Vss.n89 Vss 0.00112f
C269 Vss.n90 Vss 0
C270 Vss.n91 Vss 0.00112f
C271 Vss.n92 Vss 0.05364f
C272 Vss.n93 Vss 0.00112f
C273 Vss.n94 Vss 0
C274 Vss.n95 Vss 0.00663f
C275 Vss.n96 Vss 0
C276 Vss.n97 Vss 0.00112f
C277 Vss.n98 Vss 0.05364f
C278 Vss.n99 Vss 0.00112f
C279 Vss.n100 Vss 0
C280 Vss.n101 Vss 0.00112f
C281 Vss.n102 Vss 0
C282 Vss.n103 Vss 0.00112f
C283 Vss.n104 Vss 0.05364f
C284 Vss.n105 Vss 0.00112f
C285 Vss.n106 Vss 0
C286 Vss.n107 Vss 0.00663f
C287 Vss.n108 Vss 0
C288 Vss.n109 Vss 0.00112f
C289 Vss.n110 Vss 0.05364f
C290 Vss.n111 Vss 0.00112f
C291 Vss.n112 Vss 0
C292 Vss.n113 Vss 0.00112f
C293 Vss.n114 Vss 0
C294 Vss.n115 Vss 0.00112f
C295 Vss.n116 Vss 0.05364f
C296 Vss.n117 Vss 0.00112f
C297 Vss.n118 Vss 0
C298 Vss.n119 Vss 0.00663f
C299 Vss.n120 Vss 0
C300 Vss.n121 Vss 0.00112f
C301 Vss.n122 Vss 0.05364f
C302 Vss.n123 Vss 0.00112f
C303 Vss.n124 Vss 0
C304 Vss.n125 Vss 0.00112f
C305 Vss.n126 Vss 0
C306 Vss.n127 Vss 0.00112f
C307 Vss.n128 Vss 0.05364f
C308 Vss.n129 Vss 0.00112f
C309 Vss.n130 Vss 0
C310 Vss.n131 Vss 0.00153f
C311 Vss.n132 Vss 0.00235f
C312 Vss.n133 Vss 0.32369f
C313 Vss.n134 Vss 0.00235f
C314 Vss.n135 Vss 0
C315 Vss.n136 Vss 0
C316 Vss.n137 Vss 0
C317 Vss.n138 Vss 0
C318 Vss.n139 Vss 0
C319 Vss.n140 Vss 0
C320 Vss.n141 Vss 0
C321 Vss.n143 Vss 0
C322 Vss.n145 Vss 0
C323 Vss.n146 Vss 0
C324 Vss.n147 Vss 0
C325 Vss.n148 Vss 0
C326 Vss.n149 Vss 0
C327 Vss.n151 Vss 0
C328 Vss.n153 Vss 0
C329 Vss.n154 Vss 0
C330 Vss.n155 Vss 0
C331 Vss.n156 Vss 0
C332 Vss.n157 Vss 0
C333 Vss.n159 Vss 0
C334 Vss.n161 Vss 0
C335 Vss.n162 Vss 0
C336 Vss.n163 Vss 0
C337 Vss.n164 Vss 0
C338 Vss.n165 Vss 0
C339 Vss.n167 Vss 0
C340 Vss.n169 Vss 0
C341 Vss.n170 Vss 0
C342 Vss.n171 Vss 0.00154f
C343 Vss.n172 Vss 0.00409f
C344 Vss.n173 Vss 0
C345 Vss.n174 Vss 0.00237f
C346 Vss.n175 Vss 0.08072f
C347 Vss.n176 Vss 0.00237f
C348 Vss.n177 Vss 0
C349 Vss.n178 Vss 0.01568f
C350 Vss.n179 Vss 0.00663f
C351 Vss.n180 Vss 0.00663f
C352 Vss.n181 Vss 0
C353 Vss.n182 Vss 0.00112f
C354 Vss.n183 Vss 0.05364f
C355 Vss.n184 Vss 0.00112f
C356 Vss.n185 Vss 0
C357 Vss.n186 Vss 0.00112f
C358 Vss.n187 Vss 0.00112f
C359 Vss.n188 Vss 0.00112f
C360 Vss.n189 Vss 0
C361 Vss.n190 Vss 0.00112f
C362 Vss.n191 Vss 0.05364f
C363 Vss.n192 Vss 0.00112f
C364 Vss.n193 Vss 0
C365 Vss.n194 Vss 0.00663f
C366 Vss.n195 Vss 0.00663f
C367 Vss.n196 Vss 0.00663f
C368 Vss.n197 Vss 0
C369 Vss.n198 Vss 0.00112f
C370 Vss.n199 Vss 0.05364f
C371 Vss.n200 Vss 0.00112f
C372 Vss.n201 Vss 0
C373 Vss.n202 Vss 0.00112f
C374 Vss.n203 Vss 0.00112f
C375 Vss.n204 Vss 0.00112f
C376 Vss.n205 Vss 0
C377 Vss.n206 Vss 0.00112f
C378 Vss.n207 Vss 0.05364f
C379 Vss.n208 Vss 0.00112f
C380 Vss.n209 Vss 0
C381 Vss.n210 Vss 0.00663f
C382 Vss.n211 Vss 0.00663f
C383 Vss.n212 Vss 0.00663f
C384 Vss.n213 Vss 0
C385 Vss.n214 Vss 0.00112f
C386 Vss.n215 Vss 0.05364f
C387 Vss.n216 Vss 0.00112f
C388 Vss.n217 Vss 0
C389 Vss.n218 Vss 0.00112f
C390 Vss.n219 Vss 0.00112f
C391 Vss.n220 Vss 0.00112f
C392 Vss.n221 Vss 0
C393 Vss.n222 Vss 0.00112f
C394 Vss.n223 Vss 0.05364f
C395 Vss.n224 Vss 0.00112f
C396 Vss.n225 Vss 0
C397 Vss.n226 Vss 0.00663f
C398 Vss.n227 Vss 0.00663f
C399 Vss.n228 Vss 0.00663f
C400 Vss.n229 Vss 0
C401 Vss.n230 Vss 0.00112f
C402 Vss.n231 Vss 0.05364f
C403 Vss.n232 Vss 0.00112f
C404 Vss.n233 Vss 0
C405 Vss.n234 Vss 0.00112f
C406 Vss.n235 Vss 0.00112f
C407 Vss.n236 Vss 0.00112f
C408 Vss.n237 Vss 0
C409 Vss.n238 Vss 0.00112f
C410 Vss.n239 Vss 0.05364f
C411 Vss.n240 Vss 0.00112f
C412 Vss.n241 Vss 0
C413 Vss.n242 Vss 0.00663f
C414 Vss.n243 Vss 0.00663f
C415 Vss.n244 Vss 0.00663f
C416 Vss.n245 Vss 0
C417 Vss.n246 Vss 0.00112f
C418 Vss.n247 Vss 0.05364f
C419 Vss.n248 Vss 0.00112f
C420 Vss.n249 Vss 0
C421 Vss.n250 Vss 0.00112f
C422 Vss.n251 Vss 0.00112f
C423 Vss.n252 Vss 0.00112f
C424 Vss.n253 Vss 0
C425 Vss.n254 Vss 0.00112f
C426 Vss.n255 Vss 0.05364f
C427 Vss.n256 Vss 0.00112f
C428 Vss.n257 Vss 0
C429 Vss.n258 Vss 0.00663f
C430 Vss.n259 Vss 0.00663f
C431 Vss.n260 Vss 0.00663f
C432 Vss.n261 Vss 0
C433 Vss.n262 Vss 0.00112f
C434 Vss.n263 Vss 0.05364f
C435 Vss.n264 Vss 0.00112f
C436 Vss.n265 Vss 0
C437 Vss.n266 Vss 0.00112f
C438 Vss.n267 Vss 0.00112f
C439 Vss.n268 Vss 0.00112f
C440 Vss.n269 Vss 0
C441 Vss.n270 Vss 0.00112f
C442 Vss.n271 Vss 0.05364f
C443 Vss.n272 Vss 0.00112f
C444 Vss.n273 Vss 0
C445 Vss.n274 Vss 0.00663f
C446 Vss.n275 Vss 0.00663f
C447 Vss.n276 Vss 0.00663f
C448 Vss.n277 Vss 0
C449 Vss.n278 Vss 0.00112f
C450 Vss.n279 Vss 0.05364f
C451 Vss.n280 Vss 0.00112f
C452 Vss.n281 Vss 0
C453 Vss.n282 Vss 0.00112f
C454 Vss.n283 Vss 0.00112f
C455 Vss.n284 Vss 0.00112f
C456 Vss.n285 Vss 0.00112f
C457 Vss.n286 Vss 0
C458 Vss.n287 Vss 0.00112f
C459 Vss.n288 Vss 0.05364f
C460 Vss.n289 Vss 0.00112f
C461 Vss.n290 Vss 0
C462 Vss.n291 Vss 0.00663f
C463 Vss.n292 Vss 0.00663f
C464 Vss.n293 Vss 0.00663f
C465 Vss.n294 Vss 0
C466 Vss.n295 Vss 0.00112f
C467 Vss.n296 Vss 0.05364f
C468 Vss.n297 Vss 0.00112f
C469 Vss.n298 Vss 0.00112f
C470 Vss.n299 Vss 0
C471 Vss.n300 Vss 0.00112f
C472 Vss.n301 Vss 0.00112f
C473 Vss.n302 Vss 0.00112f
C474 Vss.n303 Vss 0
C475 Vss.n304 Vss 0.00112f
C476 Vss.n305 Vss 0.05364f
C477 Vss.n306 Vss 0.05364f
C478 Vss.n307 Vss 0.00112f
C479 Vss.n308 Vss 0
C480 Vss.n309 Vss 0.00663f
C481 Vss.n310 Vss 0.00663f
C482 Vss.n311 Vss 0.00663f
C483 Vss.n312 Vss 0
C484 Vss.n313 Vss 0.00112f
C485 Vss.n314 Vss 0.00112f
C486 Vss.n315 Vss 0.05364f
C487 Vss.n316 Vss 0.00112f
C488 Vss.n317 Vss 0
C489 Vss.n318 Vss 0.00112f
C490 Vss.n319 Vss 0.00112f
C491 Vss.n320 Vss 0.00112f
C492 Vss.n321 Vss 0.00112f
C493 Vss.n322 Vss 0.00112f
C494 Vss.n323 Vss 0
C495 Vss.n324 Vss 0.00112f
C496 Vss.n325 Vss 0.05364f
C497 Vss.n326 Vss 0.05364f
C498 Vss.n327 Vss 0.00112f
C499 Vss.n328 Vss 0.05364f
C500 Vss.n329 Vss 0.00112f
C501 Vss.n330 Vss 0.00112f
C502 Vss.n331 Vss 0
C503 Vss.n332 Vss 0
C504 Vss.n333 Vss 0.00409f
C505 Vss.n334 Vss 0.03539f
C506 Vss.n335 Vss 0.00146f
C507 Vss.n336 Vss 0
C508 Vss.n337 Vss 0
C509 Vss.n338 Vss 0
C510 Vss.n339 Vss 0
C511 Vss.n340 Vss 0.00218f
C512 Vss.n341 Vss 0.0415f
C513 Vss.n345 Vss 0
C514 Vss.n346 Vss 0.00378f
C515 Vss.n347 Vss 0.00112f
C516 Vss.n348 Vss 0.00112f
C517 Vss.n349 Vss 0.00378f
C518 Vss.n350 Vss 0.00216f
C519 Vss.n351 Vss 0.02975f
C520 Vss.n352 Vss 0.12204f
C521 Vss.n353 Vss 0.0415f
C522 Vss.n358 Vss 0
C523 Vss.n359 Vss 0.00218f
C524 Vss.n360 Vss 0
C525 Vss.n361 Vss 0.00146f
C526 Vss.n362 Vss 0
C527 Vss.n363 Vss 0.00218f
C528 Vss.n364 Vss 0.00112f
C529 Vss.n365 Vss 0.00218f
C530 Vss.n366 Vss 0.20599f
C531 Vss.n367 Vss 0.0415f
C532 Vss.n372 Vss 0
C533 Vss.n373 Vss 0.00218f
C534 Vss.n374 Vss 0
C535 Vss.n375 Vss 0.00146f
C536 Vss.n376 Vss 0
C537 Vss.n377 Vss 0.00218f
C538 Vss.n378 Vss 0.00112f
C539 Vss.n379 Vss 0.00218f
C540 Vss.n380 Vss 0.00216f
C541 Vss.n385 Vss 0
C542 Vss.n386 Vss 0.00112f
C543 Vss.n387 Vss 0.00378f
C544 Vss.n388 Vss 0
C545 Vss.n389 Vss 0
C546 Vss.n390 Vss 0
C547 Vss.n391 Vss 0
C548 Vss.n392 Vss 0
C549 Vss.n393 Vss 0
C550 Vss.n394 Vss 0
C551 Vss.n395 Vss 0
C552 Vss.n396 Vss 0
C553 Vss.n397 Vss 0
C554 Vss.n398 Vss 0
C555 Vss.n399 Vss 0
C556 Vss.n400 Vss 0.00148f
C557 Vss.n401 Vss 0.00216f
C558 Vss.n402 Vss 0.00218f
C559 Vss.n403 Vss 0
C560 Vss.n404 Vss 0
C561 Vss.n405 Vss 0
C562 Vss.n406 Vss 0.00378f
C563 Vss.n407 Vss 0
C564 Vss.n408 Vss 0
C565 Vss.n409 Vss 0
C566 Vss.n410 Vss 0
C567 Vss.n411 Vss 0
C568 Vss.n412 Vss 0
C569 Vss.n413 Vss 0
C570 Vss.n414 Vss 0
C571 Vss.n415 Vss 0
C572 Vss.n416 Vss 0
C573 Vss.n417 Vss 0
C574 Vss.n418 Vss 0.00378f
C575 Vss.n419 Vss 0
C576 Vss.n420 Vss 0.00148f
C577 Vss.n421 Vss 0.00216f
C578 Vss.n422 Vss 0.23498f
C579 Vss.n423 Vss 0.0415f
C580 Vss.n424 Vss 0.02975f
C581 Vss.n425 Vss 0.00112f
C582 Vss.n426 Vss 0
C583 Vss.n427 Vss 0
C584 Vss.n428 Vss 0.05001f
C585 Vss.n429 Vss 0.00146f
C586 Vss.n430 Vss 0.00216f
C587 Vss.n431 Vss 0.0595f
C588 Vss.n432 Vss 0.09507f
C589 Vss.n433 Vss 0.00216f
C590 Vss.n438 Vss 0
C591 Vss.n439 Vss 0.00112f
C592 Vss.n440 Vss 0.00378f
C593 Vss.n441 Vss 0
C594 Vss.n442 Vss 0
C595 Vss.n443 Vss 0
C596 Vss.n444 Vss 0
C597 Vss.n445 Vss 0
C598 Vss.n446 Vss 0
C599 Vss.n447 Vss 0
C600 Vss.n448 Vss 0
C601 Vss.n449 Vss 0
C602 Vss.n450 Vss 0
C603 Vss.n451 Vss 0
C604 Vss.n452 Vss 0
C605 Vss.n453 Vss 0.00148f
C606 Vss.n454 Vss 0.00216f
C607 Vss.n455 Vss 0.00218f
C608 Vss.n456 Vss 0
C609 Vss.n457 Vss 0
C610 Vss.n458 Vss 0
C611 Vss.n459 Vss 0.00378f
C612 Vss.n460 Vss 0
C613 Vss.n461 Vss 0
C614 Vss.n462 Vss 0
C615 Vss.n463 Vss 0
C616 Vss.n464 Vss 0
C617 Vss.n465 Vss 0
C618 Vss.n466 Vss 0
C619 Vss.n467 Vss 0
C620 Vss.n468 Vss 0
C621 Vss.n469 Vss 0
C622 Vss.n470 Vss 0
C623 Vss.n471 Vss 0.00378f
C624 Vss.n472 Vss 0
C625 Vss.n473 Vss 0.00148f
C626 Vss.n474 Vss 0.00216f
C627 Vss.n475 Vss 0.06902f
C628 Vss.n476 Vss 0.0415f
C629 Vss.n477 Vss 0.02975f
C630 Vss.n478 Vss 0.00112f
C631 Vss.n479 Vss 0
C632 Vss.n480 Vss 0
C633 Vss.n481 Vss 0.02721f
C634 Vss.n482 Vss 0.00146f
C635 Vss.n483 Vss 0.00216f
C636 Vss.n484 Vss 0.05474f
C637 Vss.n485 Vss 0.09507f
C638 Vss.n486 Vss 0.07378f
C639 Vss.n487 Vss 0
C640 Vss.n488 Vss 0.00112f
C641 Vss.n489 Vss 0
C642 Vss.n490 Vss 0
C643 Vss.n491 Vss 0
C644 Vss.n492 Vss 0.00148f
C645 Vss.n494 Vss 0
C646 Vss.n495 Vss 0
C647 Vss.n496 Vss 0.00378f
C648 Vss.n497 Vss 0
C649 Vss.n498 Vss 0
C650 Vss.n500 Vss 0
C651 Vss.n502 Vss 0
C652 Vss.n503 Vss 0
C653 Vss.n504 Vss 0
C654 Vss.n505 Vss 0
C655 Vss.n506 Vss 0
C656 Vss.n508 Vss 0.00216f
C657 Vss.n509 Vss 0.00218f
C658 Vss.n510 Vss 0.0415f
C659 Vss.n511 Vss 0.00218f
C660 Vss.n512 Vss 0
C661 Vss.n513 Vss 0
C662 Vss.n514 Vss 0
C663 Vss.n515 Vss 0.00218f
C664 Vss.n516 Vss 0.00216f
C665 Vss.n517 Vss 0.00148f
C666 Vss.n518 Vss 0
C667 Vss.n519 Vss 0
C668 Vss.n520 Vss 0
C669 Vss.n521 Vss 0
C670 Vss.n522 Vss 0
C671 Vss.n523 Vss 0
C672 Vss.n524 Vss 0
C673 Vss.n525 Vss 0
C674 Vss.n526 Vss 0
C675 Vss.n527 Vss 0
C676 Vss.n528 Vss 0
C677 Vss.n530 Vss 0.02767f
C678 Vss.n531 Vss 0.00216f
C679 Vss.n532 Vss 0.00146f
C680 Vss.n533 Vss 0.02721f
C681 Vss.n534 Vss 0.03026f
C682 Vss.n535 Vss 0.00995f
C683 Vss.n536 Vss 0.00152f
C684 Vss.n537 Vss 0
C685 Vss.n538 Vss 0
C686 Vss.n539 Vss 0
C687 Vss.n540 Vss 0
C688 Vss.n541 Vss 0
C689 Vss.n542 Vss 0
C690 Vss.n543 Vss 0
C691 Vss.n544 Vss 0
C692 Vss.n545 Vss 0
C693 Vss.n546 Vss 0
C694 Vss.n547 Vss 0
C695 Vss.n548 Vss 0
C696 Vss.n549 Vss 0
C697 Vss.n550 Vss 0
C698 Vss.n551 Vss 0
C699 Vss.n552 Vss 0
C700 Vss.n553 Vss 0
C701 Vss.n554 Vss 0
C702 Vss.n555 Vss 0
C703 Vss.n556 Vss 0
C704 Vss.n557 Vss 0
C705 Vss.n558 Vss 0
C706 Vss.n559 Vss 0
C707 Vss.n560 Vss 0
C708 Vss.n561 Vss 0
C709 Vss.n562 Vss 0.04325f
C710 Vss.n563 Vss 0.00986f
C711 Vss.n564 Vss 0.00154f
C712 Vss.n565 Vss 0.00235f
C713 Vss.n566 Vss 0.16198f
C714 Vss.n567 Vss 0.08072f
C715 Vss.n568 Vss 0.00237f
C716 Vss.n569 Vss 0
C717 Vss.n570 Vss 0
C718 Vss.n571 Vss 0.00663f
C719 Vss.n572 Vss 0.00663f
C720 Vss.n573 Vss 0.00663f
C721 Vss.n574 Vss 0
C722 Vss.n575 Vss 0
C723 Vss.n576 Vss 0
C724 Vss.n577 Vss 0.00338f
C725 Vss.n578 Vss -0.09858f
C726 Iin.n0 Vss 0.00195f
C727 Iin.n1 Vss 0.00195f
C728 Iin.n2 Vss 1.65883f
C729 Iin.n3 Vss 0.09424f
C730 Iin.n4 Vss 0.02149f
C731 spike_neg.n0 Vss 0.01247f
C732 spike_neg.n1 Vss 0.01684f
C733 spike_neg.n2 Vss 0.01241f
C734 spike_neg.n3 Vss 0.51566f
C735 spike_neg.n4 Vss 0.14366f
C736 spike_neg.n5 Vss 0.01241f
C737 spike_neg.n6 Vss 0.4327f
C738 Vdd Vss -3.86232f
C739 Iin Vss -1.83473f
C740 spike_neg Vss -1.84608f
C741 m4_0/a_28_n50# Vss 0.62898f
C742 spike Vss 0.54284f
.ends
